* SPICE NETLIST
***************************************

.SUBCKT M3_M2_S_CDNS_783599169895
** N=2 EP=0 IP=0 FDC=0
.ENDS
***************************************
.SUBCKT M3_M2_S_CDNS_783599169890
** N=2 EP=0 IP=0 FDC=0
.ENDS
***************************************
.SUBCKT M3_M2_S_CDNS_7835991698919
** N=2 EP=0 IP=0 FDC=0
.ENDS
***************************************
.SUBCKT M2_M1_S_CDNS_7835991698920
** N=1 EP=0 IP=0 FDC=0
.ENDS
***************************************
.SUBCKT ML_M3_S_CDNS_7835991698918
** N=2 EP=0 IP=0 FDC=0
.ENDS
***************************************
.SUBCKT SenseAmplifier SA_BLB VDD SA_BL SE VSS
** N=8 EP=5 IP=11 FDC=5
M0 7 SA_BLB VOUT VSS N L=1.8e-07 W=4.2e-07 $X=1035 $Y=1835 $D=2
M1 8 SA_BL 7 VSS N L=1.8e-07 W=4.2e-07 $X=1755 $Y=1835 $D=2
M2 VSS SE 7 VSS N L=1.8e-07 W=4.2e-07 $X=3255 $Y=1835 $D=2
M3 VDD 8 VOUT VDD P L=1.8e-07 W=4.2e-07 $X=1035 $Y=3125 $D=6
M4 8 8 VDD VDD P L=1.8e-07 W=4.2e-07 $X=1755 $Y=3125 $D=6
.ENDS
***************************************
.SUBCKT pmos_18_CDNS_783599169896 1 2 3 4
** N=4 EP=4 IP=0 FDC=1
M0 2 3 1 4 P L=1.8e-07 W=4.2e-07 $X=480 $Y=0 $D=6
.ENDS
***************************************
.SUBCKT nmos_18_CDNS_783599169895 1 2 3 4
** N=4 EP=4 IP=0 FDC=1
M0 2 3 1 4 N L=1.8e-07 W=4.2e-07 $X=480 $Y=0 $D=2
.ENDS
***************************************
.SUBCKT M3_M2_S_CDNS_7835991698938
** N=1 EP=0 IP=0 FDC=0
.ENDS
***************************************
.SUBCKT CMOS_INV vin vdd out vss
** N=4 EP=4 IP=11 FDC=2
X1 vdd out vin vdd pmos_18_CDNS_783599169896 $T=430 1670 0 0 $X=0 $Y=1240
X2 vss out vin vss nmos_18_CDNS_783599169895 $T=430 385 0 0 $X=250 $Y=35
.ENDS
***************************************
.SUBCKT Write_Driver 1 VDD WD_BLB WD_BL
** N=6 EP=4 IP=12 FDC=6
X0 5 VDD WD_BLB 1 CMOS_INV $T=2155 760 1 180 $X=155 $Y=175
X1 Din VDD 5 1 CMOS_INV $T=3655 760 1 180 $X=1655 $Y=175
X2 Din VDD WD_BL 1 CMOS_INV $T=3380 760 0 0 $X=3380 $Y=175
.ENDS
***************************************
.SUBCKT M2_M1_S_CDNS_783599169891
** N=1 EP=0 IP=0 FDC=0
.ENDS
***************************************
.SUBCKT M2_M1_S_CDNS_7835991698931
** N=2 EP=0 IP=0 FDC=0
.ENDS
***************************************
.SUBCKT M2_M1_S_CDNS_7835991698925
** N=1 EP=0 IP=0 FDC=0
.ENDS
***************************************
.SUBCKT M1_PO_4X_CDNS_7835991698932
** N=2 EP=0 IP=0 FDC=0
.ENDS
***************************************
.SUBCKT ColumnMux YSR 2 BLB BL 5 6 7 8 9
** N=10 EP=9 IP=72 FDC=10
X3 2 BLB YSR_BAR 9 pmos_18_CDNS_783599169896 $T=1570 3735 1 180 $X=0 $Y=3305
X4 BL 5 YSR_BAR 9 pmos_18_CDNS_783599169896 $T=3570 3735 1 180 $X=2000 $Y=3305
X5 BLB 6 YSR 9 pmos_18_CDNS_783599169896 $T=5570 3735 1 180 $X=4000 $Y=3305
X6 7 BL YSR 9 pmos_18_CDNS_783599169896 $T=7070 3735 1 180 $X=5500 $Y=3305
X7 2 BLB YSR 8 nmos_18_CDNS_783599169895 $T=1570 2450 1 180 $X=250 $Y=2100
X8 BL 5 YSR 8 nmos_18_CDNS_783599169895 $T=3570 2450 1 180 $X=2250 $Y=2100
X9 BLB 6 YSR_BAR 8 nmos_18_CDNS_783599169895 $T=5570 2450 1 180 $X=4250 $Y=2100
X10 7 BL YSR_BAR 8 nmos_18_CDNS_783599169895 $T=7070 2450 1 180 $X=5750 $Y=2100
X11 YSR 9 YSR_BAR 8 CMOS_INV $T=7500 2065 0 0 $X=7500 $Y=1480
.ENDS
***************************************
.SUBCKT ICV_1 1 2 3 4 5 6 7 8 9 10 11 12 13 14 15
** N=15 EP=15 IP=18 FDC=20
X0 15 3 6 5 4 7 8 1 2 ColumnMux $T=0 0 0 0 $X=0 $Y=-285
X1 15 9 12 11 10 13 14 1 2 ColumnMux $T=9000 0 0 0 $X=9000 $Y=-285
.ENDS
***************************************
.SUBCKT pmos_18_CDNS_783599169899 1 2 3
** N=3 EP=3 IP=0 FDC=1
M0 2 3 1 1 P L=1.8e-07 W=2.2e-07 $X=420 $Y=0 $D=6
.ENDS
***************************************
.SUBCKT nmos_18_CDNS_783599169897 1 2 3 4
** N=4 EP=4 IP=0 FDC=1
M0 2 3 1 4 N L=1.8e-07 W=2.2e-07 $X=420 $Y=0 $D=2
.ENDS
***************************************
.SUBCKT nmos_18_CDNS_783599169898 1 2 3
** N=3 EP=3 IP=0 FDC=1
M0 2 3 1 1 N L=1.8e-07 W=4.4e-07 $X=480 $Y=0 $D=2
.ENDS
***************************************
.SUBCKT SRAM WL VDD BL 4 VSS
** N=7 EP=5 IP=29 FDC=6
X6 VDD 7 6 pmos_18_CDNS_783599169899 $T=1835 3665 1 180 $X=285 $Y=3135
X7 VDD 6 7 pmos_18_CDNS_783599169899 $T=2395 3665 0 0 $X=1865 $Y=3135
X8 BL 7 WL VSS nmos_18_CDNS_783599169897 $T=1055 210 0 90 $X=385 $Y=-70
X9 6 4 WL VSS nmos_18_CDNS_783599169897 $T=3170 1230 0 270 $X=2720 $Y=-70
X10 VSS 7 6 nmos_18_CDNS_783599169898 $T=1895 1860 1 180 $X=575 $Y=1510
X11 VSS 6 7 nmos_18_CDNS_783599169898 $T=2335 1860 0 0 $X=2155 $Y=1510
.ENDS
***************************************
.SUBCKT ICV_2 1 2 3 4 5 6 7
** N=7 EP=7 IP=10 FDC=12
X0 2 7 3 4 1 SRAM $T=0 0 0 0 $X=-260 $Y=-545
X1 2 7 5 6 1 SRAM $T=3895 0 0 0 $X=3635 $Y=-545
.ENDS
***************************************
.SUBCKT ICV_3 1 2 3 4 5 6 7 8 9 10 11 12 13 14
** N=14 EP=14 IP=56 FDC=96
X0 1 2 10 11 12 13 14 ICV_2 $T=0 0 0 0 $X=-260 $Y=-545
X1 1 3 10 11 12 13 14 ICV_2 $T=0 5565 0 0 $X=-260 $Y=5020
X2 1 4 10 11 12 13 14 ICV_2 $T=0 11010 0 0 $X=-260 $Y=10465
X3 1 5 10 11 12 13 14 ICV_2 $T=0 16395 0 0 $X=-260 $Y=15850
X4 1 6 10 11 12 13 14 ICV_2 $T=0 21880 0 0 $X=-260 $Y=21335
X5 1 7 10 11 12 13 14 ICV_2 $T=0 27310 0 0 $X=-260 $Y=26765
X6 1 8 10 11 12 13 14 ICV_2 $T=0 32790 0 0 $X=-260 $Y=32245
X7 1 9 10 11 12 13 14 ICV_2 $T=0 38245 0 0 $X=-260 $Y=37700
.ENDS
***************************************
.SUBCKT Precharge_Circuit 1 BL BLB 4 5
** N=6 EP=5 IP=8 FDC=5
M0 BL 6 1 1 P L=1.8e-07 W=4.2e-07 $X=2650 $Y=2335 $D=6
M1 BLB 6 BL 1 P L=1.8e-07 W=4.2e-07 $X=3370 $Y=2335 $D=6
M2 1 6 BLB 1 P L=1.8e-07 W=4.2e-07 $X=4090 $Y=2335 $D=6
X5 5 1 6 4 CMOS_INV $T=240 665 0 0 $X=240 $Y=80
.ENDS
***************************************
.SUBCKT ICV_4 1 2 3 4 5 6 7
** N=7 EP=7 IP=10 FDC=10
X0 7 5 3 1 2 Precharge_Circuit $T=0 0 0 0 $X=240 $Y=80
X1 7 6 4 1 2 Precharge_Circuit $T=4440 0 0 0 $X=4680 $Y=80
.ENDS
***************************************
.SUBCKT M3_M2_S_CDNS_783599169898
** N=2 EP=0 IP=0 FDC=0
.ENDS
***************************************
.SUBCKT INVERTER vin vdd out vss
** N=4 EP=4 IP=9 FDC=2
X0 vdd out vin vdd pmos_18_CDNS_783599169896 $T=430 1640 0 0 $X=0 $Y=1210
X1 vss out vin vss nmos_18_CDNS_783599169895 $T=430 350 0 0 $X=250 $Y=0
.ENDS
***************************************
.SUBCKT NAND C B A 4 Y 6
** N=8 EP=6 IP=29 FDC=6
X0 4 Y C 4 pmos_18_CDNS_783599169896 $T=430 1640 0 0 $X=0 $Y=1210
X1 4 Y B 4 pmos_18_CDNS_783599169896 $T=2290 1640 1 180 $X=720 $Y=1210
X2 4 Y A 4 pmos_18_CDNS_783599169896 $T=1870 1640 0 0 $X=1440 $Y=1210
X3 6 7 C 6 nmos_18_CDNS_783599169895 $T=430 350 0 0 $X=250 $Y=0
X4 7 8 B 6 nmos_18_CDNS_783599169895 $T=1150 350 0 0 $X=970 $Y=0
X5 8 Y A 6 nmos_18_CDNS_783599169895 $T=1870 350 0 0 $X=1690 $Y=0
.ENDS
***************************************
.SUBCKT 3_8_DECODER VDD VSS Y0 Y1 Y2 Y3 Y4 Y5 Y6 Y7
** N=24 EP=10 IP=134 FDC=70
X42 A VDD 13 VSS INVERTER $T=645 3445 0 0 $X=645 $Y=2810
X43 B VDD 12 VSS INVERTER $T=2645 3445 0 0 $X=2645 $Y=2810
X44 C VDD 11 VSS INVERTER $T=4645 3445 0 0 $X=4645 $Y=2810
X45 17 VDD Y0 VSS INVERTER $T=10085 3445 0 0 $X=10085 $Y=2810
X46 18 VDD Y1 VSS INVERTER $T=15525 3445 0 0 $X=15525 $Y=2810
X47 19 VDD Y2 VSS INVERTER $T=20965 3445 0 0 $X=20965 $Y=2810
X48 20 VDD Y3 VSS INVERTER $T=26405 3445 0 0 $X=26405 $Y=2810
X49 21 VDD Y4 VSS INVERTER $T=31845 3455 0 0 $X=31845 $Y=2820
X50 22 VDD Y5 VSS INVERTER $T=37285 3445 0 0 $X=37285 $Y=2810
X51 23 VDD Y6 VSS INVERTER $T=42725 3455 0 0 $X=42725 $Y=2820
X52 24 VDD Y7 VSS INVERTER $T=48165 3445 0 0 $X=48165 $Y=2810
X53 11 12 13 VDD 17 VSS NAND $T=6645 3445 0 0 $X=6645 $Y=2810
X54 C 12 13 VDD 18 VSS NAND $T=12085 3445 0 0 $X=12085 $Y=2810
X55 11 B 13 VDD 19 VSS NAND $T=17525 3445 0 0 $X=17525 $Y=2810
X56 C B 13 VDD 20 VSS NAND $T=22965 3445 0 0 $X=22965 $Y=2810
X57 11 12 A VDD 21 VSS NAND $T=28405 3445 0 0 $X=28405 $Y=2810
X58 C 12 A VDD 22 VSS NAND $T=33845 3445 0 0 $X=33845 $Y=2810
X59 11 B A VDD 23 VSS NAND $T=39285 3445 0 0 $X=39285 $Y=2810
X60 C B A VDD 24 VSS NAND $T=44725 3445 0 0 $X=44725 $Y=2810
.ENDS
***************************************
.SUBCKT SRAM_ARRAY VDD VSS PRE WL6 WL7 WL4 WL1 WL0 WL2 WL3 WL_EN YSR SE
** N=62 EP=13 IP=464 FDC=662
X109 8 VDD 45 SE VSS SenseAmplifier $T=25705 -92005 0 0 $X=25705 $Y=-92690
X110 12 VDD 48 SE VSS SenseAmplifier $T=34705 -92005 0 0 $X=34705 $Y=-92690
X111 23 VDD 50 SE VSS SenseAmplifier $T=43705 -92005 0 0 $X=43705 $Y=-92690
X112 27 VDD 52 SE VSS SenseAmplifier $T=52705 -92005 0 0 $X=52705 $Y=-92690
X113 34 VDD 54 SE VSS SenseAmplifier $T=61705 -92005 0 0 $X=61705 $Y=-92690
X114 39 VDD 56 SE VSS SenseAmplifier $T=70705 -92005 0 0 $X=70705 $Y=-92690
X115 41 VDD 58 SE VSS SenseAmplifier $T=79705 -92005 0 0 $X=79705 $Y=-92690
X116 43 VDD 60 SE VSS SenseAmplifier $T=88705 -92005 0 0 $X=88705 $Y=-92690
X117 VSS VDD 5 44 Write_Driver $T=18580 -86670 0 0 $X=18735 $Y=-86930
X118 VSS VDD 9 47 Write_Driver $T=27580 -86670 0 0 $X=27735 $Y=-86930
X119 VSS VDD 20 49 Write_Driver $T=36580 -86670 0 0 $X=36735 $Y=-86930
X120 VSS VDD 24 51 Write_Driver $T=45580 -86670 0 0 $X=45735 $Y=-86930
X121 VSS VDD 30 53 Write_Driver $T=54580 -86670 0 0 $X=54735 $Y=-86930
X122 VSS VDD 36 55 Write_Driver $T=63580 -86670 0 0 $X=63735 $Y=-86930
X123 VSS VDD 40 57 Write_Driver $T=72580 -86670 0 0 $X=72735 $Y=-86930
X124 VSS VDD 42 59 Write_Driver $T=81580 -86670 0 0 $X=81735 $Y=-86930
X133 VSS VDD 5 44 6 7 8 45 9 47 4 11 12 48 YSR ICV_1 $T=20680 -80390 0 0 $X=20680 $Y=-80675
X134 VSS VDD 20 49 21 22 23 50 24 51 25 26 27 52 YSR ICV_1 $T=38680 -80390 0 0 $X=38680 $Y=-80675
X135 VSS VDD 30 53 28 29 34 54 36 55 31 32 39 56 YSR ICV_1 $T=56680 -80390 0 0 $X=56680 $Y=-80675
X136 VSS VDD 40 57 33 35 41 58 42 59 37 38 43 60 YSR ICV_1 $T=74680 -80390 0 0 $X=74680 $Y=-80675
X137 VSS WL7 WL6 10 WL4 WL3 WL2 WL1 WL0 6 7 4 11 VDD ICV_3 $T=36250 -62425 0 0 $X=35990 $Y=-62970
X138 VSS WL7 WL6 10 WL4 WL3 WL2 WL1 WL0 21 22 25 26 VDD ICV_3 $T=44040 -62425 0 0 $X=43780 $Y=-62970
X139 VSS WL7 WL6 10 WL4 WL3 WL2 WL1 WL0 28 29 31 32 VDD ICV_3 $T=51830 -62425 0 0 $X=51570 $Y=-62970
X140 VSS WL7 WL6 10 WL4 WL3 WL2 WL1 WL0 33 35 37 38 VDD ICV_3 $T=59620 -62425 0 0 $X=59360 $Y=-62970
X141 VSS PRE 7 11 6 4 VDD ICV_4 $T=31480 -69825 0 0 $X=31720 $Y=-69745
X142 VSS PRE 22 26 21 25 VDD ICV_4 $T=40360 -69825 0 0 $X=40600 $Y=-69745
X143 VSS PRE 29 32 28 31 VDD ICV_4 $T=49240 -69825 0 0 $X=49480 $Y=-69745
X144 VSS PRE 35 38 33 37 VDD ICV_4 $T=58120 -69825 0 0 $X=58360 $Y=-69745
X151 WL_EN VSS WL0 WL1 WL2 WL3 WL4 10 WL6 WL7 3_8_DECODER $T=35550 -11400 1 270 $X=23390 $Y=-63210
.ENDS
***************************************
