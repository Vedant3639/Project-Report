* SPICE NETLIST
***************************************

.SUBCKT M3_M2_S_CDNS_783527285045
** N=1 EP=0 IP=0 FDC=0
.ENDS
***************************************
.SUBCKT Precharge_Circuit BL BLB
** N=6 EP=2 IP=2 FDC=5
M0 4 3 2 2 N L=1.8e-07 W=4.2e-07 $X=1150 $Y=1050 $D=2
M1 4 3 1 1 P L=1.8e-07 W=4.2e-07 $X=1150 $Y=2335 $D=6
M2 BL 4 1 1 P L=1.8e-07 W=4.2e-07 $X=2650 $Y=2335 $D=6
M3 BLB 4 BL 1 P L=1.8e-07 W=4.2e-07 $X=3370 $Y=2335 $D=6
M4 1 4 BLB 1 P L=1.8e-07 W=4.2e-07 $X=4090 $Y=2335 $D=6
.ENDS
***************************************
