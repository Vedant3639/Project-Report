ADE simulation setup
Run mode: Monte Carlo Sampling
Tests:
  VEDANT_NEW:6TSRAM:1: VEDANT_NEW/6TSRAM/schematic, simulator spectre
Global variables:
  VIN = 1.8
  BL = 1.8
  BLB = 1.8
  VDD = 1.8
  VSS = 0
  WL = 1.8
Corners (nominal off):
  model folders: /progs/FOUNDRY/SCL_FILES/scl_pdk/design_kit/models/hspice
  ff: ts18sl_scl_mat.lib[ff_18]
  fs: ts18sl_scl_mat.lib[fs_18]
  sf: ts18sl_scl_mat.lib[sf_18]
  ss: ts18sl_scl_mat.lib[ss_18]
Monte Carlo Sampling options: mcmethod=all, mcnumpoints=10
