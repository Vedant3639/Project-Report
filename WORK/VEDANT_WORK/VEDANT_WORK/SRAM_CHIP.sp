* SPICE NETLIST
***************************************

.SUBCKT pfeed30000
** N=6 EP=0 IP=0 FDC=0
.ENDS
***************************************
.SUBCKT subil_nwellres 1 2
** N=3 EP=2 IP=0 FDC=1
R0 1 2 4891.48 L=8.65e-06 W=2.1e-06 $[RW] $X=2060 $Y=720 $D=37
.ENDS
***************************************
.SUBCKT subil_pngatering_440
** N=4 EP=0 IP=0 FDC=0
.ENDS
***************************************
.SUBCKT subil_pngatebuffsing_503 2 3 4
** N=7 EP=3 IP=0 FDC=1
M0 2 3 4 2 NH L=5e-07 W=3e-05 $X=26020 $Y=5150 $D=1
.ENDS
***************************************
.SUBCKT subil_pngate2buffsing 2 3 4
** N=7 EP=3 IP=14 FDC=2
X0 2 3 4 subil_pngatebuffsing_503 $T=0 6220 1 0 $X=16000 $Y=-2070
X1 2 3 4 subil_pngatebuffsing_503 $T=0 2640 0 0 $X=16000 $Y=1080
.ENDS
***************************************
.SUBCKT ICV_1 1 3 4
** N=7 EP=3 IP=14 FDC=4
X0 3 1 4 subil_pngate2buffsing $T=0 -9440 0 0 $X=16000 $Y=-11510
X1 3 1 4 subil_pngate2buffsing $T=0 0 0 0 $X=16000 $Y=-2070
.ENDS
***************************************
.SUBCKT subil_ppolyres 1 2
** N=3 EP=2 IP=0 FDC=1
R0 1 2 302.279 L=2.5e-06 W=4e-06 $[RE] $X=140 $Y=5120 $D=28
.ENDS
***************************************
.SUBCKT asubil_pdiodepower
** N=2 EP=0 IP=0 FDC=0
.ENDS
***************************************
.SUBCKT subil_dio2
** N=2 EP=0 IP=4 FDC=0
.ENDS
***************************************
.SUBCKT subil_psegment
** N=2 EP=0 IP=0 FDC=0
.ENDS
***************************************
.SUBCKT subil_cornerarray
** N=2 EP=0 IP=0 FDC=0
.ENDS
***************************************
.SUBCKT subil_via1array
** N=2 EP=0 IP=0 FDC=0
.ENDS
***************************************
.SUBCKT subil_pad
** N=2 EP=0 IP=14 FDC=0
.ENDS
***************************************
.SUBCKT subil_ppgatebuff 2 3 4
** N=4 EP=3 IP=0 FDC=1
M0 2 3 4 2 PH L=4e-07 W=5.2e-05 $X=10090 $Y=4110 $D=8
.ENDS
***************************************
.SUBCKT subil_ppgate2buff 2 3 4
** N=4 EP=3 IP=8 FDC=2
X0 2 3 4 subil_ppgatebuff $T=1480 3020 1 0 $X=4750 $Y=-4550
X1 2 3 4 subil_ppgatebuff $T=1480 -560 0 0 $X=4750 $Y=-1860
.ENDS
***************************************
.SUBCKT subil_ppbuff3d00_ESD 2 3 4
** N=4 EP=3 IP=16 FDC=12
M0 4 3 2 2 PH L=4e-07 W=5.2e-05 $X=10500 $Y=-460 $D=8
M1 2 3 4 2 PH L=4e-07 W=5.2e-05 $X=10500 $Y=4580 $D=8
M2 4 3 2 2 PH L=4e-07 W=5.2e-05 $X=10500 $Y=35840 $D=8
M3 2 3 4 2 PH L=4e-07 W=5.2e-05 $X=10500 $Y=40880 $D=8
X4 2 3 4 subil_ppgate2buff $T=-1070 8290 0 0 $X=3680 $Y=3740
X5 2 3 4 subil_ppgate2buff $T=-1070 15550 0 0 $X=3680 $Y=11000
X6 2 3 4 subil_ppgate2buff $T=-1070 22810 0 0 $X=3680 $Y=18260
X7 2 3 4 subil_ppgate2buff $T=-1070 30070 0 0 $X=3680 $Y=25520
.ENDS
***************************************
.SUBCKT subil_preside
** N=4 EP=0 IP=0 FDC=0
.ENDS
***************************************
.SUBCKT subil_pnesd3d00
** N=3 EP=0 IP=0 FDC=0
.ENDS
***************************************
.SUBCKT M2_M1_CDNS_784540682317
** N=1 EP=0 IP=0 FDC=0
.ENDS
***************************************
.SUBCKT M3_M2_CDNS_784540682316
** N=1 EP=0 IP=0 FDC=0
.ENDS
***************************************
.SUBCKT subil_ppdrive3d00_ESD 1 5 6
** N=10 EP=3 IP=18 FDC=1
M0 1 5 6 1 NH L=4e-07 W=3e-05 $X=31540 $Y=92610 $D=1
.ENDS
***************************************
.SUBCKT pc3d00 PAD VSS VDDO VSSO
** N=12 EP=4 IP=59 FDC=44
*.CALIBRE ISOLATED NETS: VDD
D0 VSS VSSO P3 AREA=1.331e-11 PJ=2.862e-05 $X=4765 $Y=140450 $D=54
D1 VSS VSSO P3 AREA=1.331e-11 PJ=2.862e-05 $X=7565 $Y=140450 $D=54
D2 VSS VSSO P3 AREA=1.331e-11 PJ=2.862e-05 $X=10365 $Y=140450 $D=54
D3 VSS VSSO P3 AREA=1.331e-11 PJ=2.862e-05 $X=13165 $Y=140450 $D=54
D4 VSS VSSO P3 AREA=1.331e-11 PJ=2.862e-05 $X=15965 $Y=140450 $D=54
D5 VSS VSSO P3 AREA=1.331e-11 PJ=2.862e-05 $X=18765 $Y=140450 $D=54
D6 VSS VSSO P3 AREA=1.331e-11 PJ=2.862e-05 $X=21565 $Y=140450 $D=54
D7 VSSO VSS P3 AREA=1.331e-11 PJ=2.862e-05 $X=29765 $Y=140450 $D=54
D8 VSSO VSS P3 AREA=1.331e-11 PJ=2.862e-05 $X=32565 $Y=140450 $D=54
D9 VSSO VSS P3 AREA=1.331e-11 PJ=2.862e-05 $X=35365 $Y=140450 $D=54
D10 VSSO VSS P3 AREA=1.331e-11 PJ=2.862e-05 $X=38165 $Y=140450 $D=54
D11 VSSO VSS P3 AREA=1.331e-11 PJ=2.862e-05 $X=40965 $Y=140450 $D=54
D12 VSSO VSS P3 AREA=1.331e-11 PJ=2.862e-05 $X=43765 $Y=140450 $D=54
D13 VSSO VSS P3 AREA=1.331e-11 PJ=2.862e-05 $X=46565 $Y=140450 $D=54
R14 VSS 9 1190.92 L=2.1e-06 W=2.1e-06 $[RW] $X=52650 $Y=141995 $D=37
X15 10 VSSO subil_nwellres $T=59235 139640 0 90 $X=56235 $Y=140800
X16 11 VDDO subil_nwellres $T=63600 139690 0 90 $X=60600 $Y=140850
X19 10 VSSO PAD ICV_1 $T=13400 151690 1 270 $X=2470 $Y=87580
X20 10 VSSO PAD ICV_1 $T=32280 151690 1 270 $X=21350 $Y=87580
X21 10 VSSO PAD ICV_1 $T=51160 151690 1 270 $X=40230 $Y=87580
X22 PADR 8 subil_ppolyres $T=18015 135660 0 270 $X=21585 $Y=131300
X23 8 PAD subil_ppolyres $T=34830 135670 0 270 $X=38400 $Y=131310
X26 VDDO 11 PAD subil_ppbuff3d00_ESD $T=-4000 203800 0 0 $X=-350 $Y=196990
X27 VSS 9 PADR subil_ppdrive3d00_ESD $T=-15160 89730 0 0 $X=-920 $Y=92510
.ENDS
***************************************
.SUBCKT subil_midconer2
** N=5 EP=0 IP=0 FDC=0
.ENDS
***************************************
.SUBCKT pfrelr
** N=5 EP=0 IP=10 FDC=0
*.CALIBRE ISOLATED NETS: VSS VDDO VDD VSSO
.ENDS
***************************************
.SUBCKT M2_M1_S_CDNS_784540682313
** N=1 EP=0 IP=0 FDC=0
.ENDS
***************************************
.SUBCKT M3_M2_S_CDNS_784540682311
** N=1 EP=0 IP=0 FDC=0
.ENDS
***************************************
.SUBCKT pmos_18_CDNS_784540682310 1 2 3 4
** N=4 EP=4 IP=0 FDC=1
M0 2 3 1 4 P L=1.8e-07 W=4.2e-07 $X=480 $Y=0 $D=6
.ENDS
***************************************
.SUBCKT nmos_18_CDNS_784540682311 1 2 3 4
** N=4 EP=4 IP=0 FDC=1
M0 2 3 1 4 N L=1.8e-07 W=4.2e-07 $X=480 $Y=0 $D=2
.ENDS
***************************************
.SUBCKT ML_M3_S_CDNS_7845406823121
** N=1 EP=0 IP=0 FDC=0
.ENDS
***************************************
.SUBCKT M3_M2_S_CDNS_7845406823117
** N=1 EP=0 IP=0 FDC=0
.ENDS
***************************************
.SUBCKT CMOS_inv VIN VDD OUT VSS
** N=4 EP=4 IP=10 FDC=2
X0 VDD OUT VIN VDD pmos_18_CDNS_784540682310 $T=430 1640 0 0 $X=0 $Y=1210
X1 VSS OUT VIN VSS nmos_18_CDNS_784540682311 $T=430 350 0 0 $X=250 $Y=0
.ENDS
***************************************
.SUBCKT M2_M1_S_CDNS_784540682315
** N=1 EP=0 IP=0 FDC=0
.ENDS
***************************************
.SUBCKT Write_Driver 1 WD_BL DIN WD_BLB 5
** N=6 EP=5 IP=13 FDC=6
X0 6 1 WD_BL 5 CMOS_inv $T=25 1570 0 0 $X=0 $Y=845
X1 DIN 1 WD_BLB 5 CMOS_inv $T=2025 1570 0 0 $X=2000 $Y=845
X2 DIN 1 6 5 CMOS_inv $T=4025 1570 0 0 $X=4000 $Y=845
.ENDS
***************************************
.SUBCKT M2_M1_S_CDNS_7845406823124
** N=1 EP=0 IP=0 FDC=0
.ENDS
***************************************
.SUBCKT M3_M2_S_CDNS_7845406823125
** N=2 EP=0 IP=0 FDC=0
.ENDS
***************************************
.SUBCKT M2_M1_S_CDNS_7845406823114
** N=1 EP=0 IP=0 FDC=0
.ENDS
***************************************
.SUBCKT pmos_18_CDNS_784540682315 1 2 3
** N=3 EP=3 IP=0 FDC=1
M0 2 3 1 1 P L=1.8e-07 W=4.2e-07 $X=480 $Y=0 $D=6
.ENDS
***************************************
.SUBCKT Diff_Sense_Amp SE 2 3 VOUT 5 VDD
** N=8 EP=6 IP=15 FDC=5
M0 8 2 7 5 N L=1.8e-07 W=4.2e-07 $X=2625 $Y=1300 $D=2
M1 VOUT 3 8 5 N L=1.8e-07 W=4.2e-07 $X=3345 $Y=1300 $D=2
M2 VOUT 7 VDD VDD P L=1.8e-07 W=4.2e-07 $X=3345 $Y=2840 $D=6
X3 5 8 SE 5 nmos_18_CDNS_784540682311 $T=645 1300 0 0 $X=465 $Y=950
X11 VDD 7 7 pmos_18_CDNS_784540682315 $T=3285 2840 1 180 $X=1715 $Y=2410
.ENDS
***************************************
.SUBCKT M3_M2_S_CDNS_7845406823112
** N=1 EP=0 IP=0 FDC=0
.ENDS
***************************************
.SUBCKT Column_Mux 1 BL SA_BL BLB SA_BLB WD_BL WD_BLB 8 9
** N=10 EP=9 IP=59 FDC=10
X3 BL SA_BL 1 8 pmos_18_CDNS_784540682310 $T=2430 3560 0 0 $X=2000 $Y=3130
X4 BLB SA_BLB 1 8 pmos_18_CDNS_784540682310 $T=4430 3560 0 0 $X=4000 $Y=3130
X5 BL WD_BL 10 8 pmos_18_CDNS_784540682310 $T=6430 3560 0 0 $X=6000 $Y=3130
X6 BLB WD_BLB 10 8 pmos_18_CDNS_784540682310 $T=8430 3560 0 0 $X=8000 $Y=3130
X7 SA_BL BL 10 9 nmos_18_CDNS_784540682311 $T=3565 2270 1 180 $X=2245 $Y=1920
X8 SA_BLB BLB 10 9 nmos_18_CDNS_784540682311 $T=5575 2270 1 180 $X=4255 $Y=1920
X9 WD_BL BL 1 9 nmos_18_CDNS_784540682311 $T=7570 2270 1 180 $X=6250 $Y=1920
X10 WD_BLB BLB 1 9 nmos_18_CDNS_784540682311 $T=9570 2270 1 180 $X=8250 $Y=1920
X11 1 8 10 9 CMOS_inv $T=0 1920 0 0 $X=-25 $Y=1195
.ENDS
***************************************
.SUBCKT ICV_2 1 2 3 4 5 6 7 8 9 10 11 12 13 14 15
** N=15 EP=15 IP=18 FDC=20
X0 3 4 5 6 7 8 9 1 2 Column_Mux $T=0 0 0 0 $X=-25 $Y=-5
X1 3 10 11 12 13 14 15 1 2 Column_Mux $T=10000 0 0 0 $X=9975 $Y=-5
.ENDS
***************************************
.SUBCKT pmos_18_CDNS_784540682319 1 2 3
** N=3 EP=3 IP=0 FDC=1
M0 2 3 1 1 P L=1.8e-07 W=2.2e-07 $X=420 $Y=0 $D=6
.ENDS
***************************************
.SUBCKT nmos_18_CDNS_7845406823110 1 2 3 4
** N=4 EP=4 IP=0 FDC=1
M0 2 3 1 4 N L=1.8e-07 W=2.2e-07 $X=420 $Y=0 $D=2
.ENDS
***************************************
.SUBCKT nmos_18_CDNS_784540682318 1 2 3
** N=3 EP=3 IP=0 FDC=1
M0 2 3 1 1 N L=1.8e-07 W=4.4e-07 $X=480 $Y=0 $D=2
.ENDS
***************************************
.SUBCKT M3_M2_S_CDNS_7845406823128
** N=2 EP=0 IP=0 FDC=0
.ENDS
***************************************
.SUBCKT M2_M1_S_CDNS_7845406823129
** N=2 EP=0 IP=0 FDC=0
.ENDS
***************************************
.SUBCKT SRAM WL VDD BL BLB VSS
** N=7 EP=5 IP=33 FDC=6
X4 VDD 7 6 pmos_18_CDNS_784540682319 $T=2040 4110 1 180 $X=490 $Y=3580
X5 VDD 6 7 pmos_18_CDNS_784540682319 $T=2600 4110 0 0 $X=2070 $Y=3580
X6 BL 7 WL VSS nmos_18_CDNS_7845406823110 $T=1280 660 0 90 $X=610 $Y=380
X7 6 BLB WL VSS nmos_18_CDNS_7845406823110 $T=3620 1680 1 270 $X=2950 $Y=380
X8 VSS 7 6 nmos_18_CDNS_784540682318 $T=2100 2310 1 180 $X=780 $Y=1960
X9 VSS 6 7 nmos_18_CDNS_784540682318 $T=2540 2310 0 0 $X=2360 $Y=1960
.ENDS
***************************************
.SUBCKT ICV_3 1 2 3 4 5 6
** N=6 EP=6 IP=10 FDC=12
X0 1 3 5 6 2 SRAM $T=0 0 0 0 $X=-25 $Y=0
X1 4 3 5 6 2 SRAM $T=10 5435 0 0 $X=-15 $Y=5435
.ENDS
***************************************
.SUBCKT M3_M2_S_CDNS_7845406823126
** N=2 EP=0 IP=0 FDC=0
.ENDS
***************************************
.SUBCKT Pre_charge_CKT BL BLB 3 4 5
** N=6 EP=5 IP=14 FDC=5
M0 BLB 6 BL 3 P L=1.8e-07 W=4.2e-07 $X=3655 $Y=2365 $D=6
M1 3 6 BLB 3 P L=1.8e-07 W=4.2e-07 $X=4375 $Y=2365 $D=6
X2 3 BL 6 3 pmos_18_CDNS_784540682310 $T=2455 2785 1 0 $X=2025 $Y=1935
X4 4 3 6 5 CMOS_inv $T=25 725 0 0 $X=0 $Y=0
.ENDS
***************************************
.SUBCKT ICV_4 1 2 3 4 5 6
** N=6 EP=6 IP=10 FDC=12
X0 1 3 5 6 2 SRAM $T=0 0 0 0 $X=-25 $Y=0
X1 4 3 5 6 2 SRAM $T=0 5440 0 0 $X=-25 $Y=5440
.ENDS
***************************************
.SUBCKT ICV_5 1 2 3 4 5 6 7 8 9 10 11 12
** N=12 EP=12 IP=28 FDC=48
X0 1 3 11 12 2 SRAM $T=0 21760 0 0 $X=-25 $Y=21760
X1 4 3 11 12 2 SRAM $T=0 27195 0 0 $X=-25 $Y=27195
X2 5 2 3 6 11 12 ICV_3 $T=-5 32640 0 0 $X=-30 $Y=32640
X3 7 2 3 8 11 12 ICV_4 $T=0 0 0 0 $X=-25 $Y=0
X4 9 2 3 10 11 12 ICV_4 $T=0 10880 0 0 $X=-25 $Y=10880
.ENDS
***************************************
.SUBCKT ICV_6 1 2 3 4 5 6 7
** N=7 EP=7 IP=10 FDC=10
X0 4 5 1 2 3 Pre_charge_CKT $T=0 0 0 0 $X=0 $Y=0
X1 6 7 1 2 3 Pre_charge_CKT $T=5465 0 0 0 $X=5465 $Y=0
.ENDS
***************************************
.SUBCKT ICV_7 1 2 3 4 5 6 7
** N=7 EP=7 IP=10 FDC=12
X0 1 3 4 5 2 SRAM $T=0 0 0 0 $X=-25 $Y=0
X1 1 3 6 7 2 SRAM $T=4940 0 0 0 $X=4915 $Y=0
.ENDS
***************************************
.SUBCKT nmos_18_CDNS_7845406823111 1 2 3 4
** N=4 EP=4 IP=0 FDC=1
M0 2 3 1 4 N L=1.8e-07 W=4.2e-07 $X=480 $Y=0 $D=2
.ENDS
***************************************
.SUBCKT NAND_3IP 1 C Y B A VSS
** N=8 EP=6 IP=20 FDC=6
M0 Y C 1 1 P L=1.8e-07 W=4.2e-07 $X=910 $Y=1640 $D=6
M1 1 B Y 1 P L=1.8e-07 W=4.2e-07 $X=1630 $Y=1640 $D=6
X7 1 Y A pmos_18_CDNS_784540682315 $T=1870 1640 0 0 $X=1540 $Y=1210
X8 VSS 7 C VSS nmos_18_CDNS_7845406823111 $T=430 350 0 0 $X=250 $Y=0
X9 7 8 B VSS nmos_18_CDNS_7845406823111 $T=1150 350 0 0 $X=970 $Y=0
X10 8 Y A VSS nmos_18_CDNS_7845406823111 $T=1870 350 0 0 $X=1690 $Y=0
.ENDS
***************************************
.SUBCKT 6TSRAM_ARRAY VDD EN VSS 4 5 6 OUT0 OUT1 OUT2 OUT3 OUT4 OUT5 OUT6 OUT7 PRE YSR SE D0 D1 D2
+ D3 D4 D5 D6 D7
** N=92 EP=25 IP=614 FDC=662
X128 26 EN WL7 VSS CMOS_inv $T=17760 22365 1 270 $X=14840 $Y=20365
X129 28 EN WL6 VSS CMOS_inv $T=17760 27805 1 270 $X=14840 $Y=25805
X130 30 EN WL4 VSS CMOS_inv $T=17760 38685 1 270 $X=14840 $Y=36685
X131 32 EN WL5 VSS CMOS_inv $T=17765 33245 1 270 $X=14845 $Y=31245
X132 34 EN WL3 VSS CMOS_inv $T=17765 44125 1 270 $X=14845 $Y=42125
X133 36 EN WL2 VSS CMOS_inv $T=17765 49565 1 270 $X=14845 $Y=47565
X134 38 EN WL1 VSS CMOS_inv $T=17765 55005 1 270 $X=14845 $Y=53005
X135 40 EN WL0 VSS CMOS_inv $T=17765 60445 1 270 $X=14845 $Y=58445
X136 4 EN 42 VSS CMOS_inv $T=17765 65885 1 270 $X=14845 $Y=63885
X137 5 EN 43 VSS CMOS_inv $T=17765 67885 1 270 $X=14845 $Y=65885
X138 6 EN 44 VSS CMOS_inv $T=17765 69885 1 270 $X=14845 $Y=67885
X196 VDD 76 D0 77 VSS Write_Driver $T=5955 0 0 0 $X=5955 $Y=0
X197 VDD 79 D1 80 VSS Write_Driver $T=15955 0 0 0 $X=15955 $Y=0
X198 VDD 81 D2 82 VSS Write_Driver $T=25955 0 0 0 $X=25955 $Y=0
X199 VDD 83 D3 84 VSS Write_Driver $T=35955 0 0 0 $X=35955 $Y=0
X200 VDD 85 D4 86 VSS Write_Driver $T=45955 0 0 0 $X=45955 $Y=0
X201 VDD 87 D5 88 VSS Write_Driver $T=55955 0 0 0 $X=55955 $Y=0
X202 VDD 89 D6 90 VSS Write_Driver $T=65955 0 0 0 $X=65955 $Y=0
X203 VDD 91 D7 92 VSS Write_Driver $T=75955 0 0 0 $X=75955 $Y=0
X204 SE 45 46 OUT0 VSS VDD Diff_Sense_Amp $T=1545 370 0 0 $X=1780 $Y=370
X205 SE 47 48 OUT1 VSS VDD Diff_Sense_Amp $T=11545 370 0 0 $X=11780 $Y=370
X206 SE 49 50 OUT2 VSS VDD Diff_Sense_Amp $T=21545 370 0 0 $X=21780 $Y=370
X207 SE 51 52 OUT3 VSS VDD Diff_Sense_Amp $T=31545 370 0 0 $X=31780 $Y=370
X208 SE 53 54 OUT4 VSS VDD Diff_Sense_Amp $T=41545 370 0 0 $X=41780 $Y=370
X209 SE 55 56 OUT5 VSS VDD Diff_Sense_Amp $T=51545 370 0 0 $X=51780 $Y=370
X210 SE 57 58 OUT6 VSS VDD Diff_Sense_Amp $T=61370 370 0 0 $X=61605 $Y=370
X211 SE 59 60 OUT7 VSS VDD Diff_Sense_Amp $T=71540 370 0 0 $X=71775 $Y=370
X212 VDD VSS YSR 61 45 62 46 76 77 63 47 64 48 79 80 ICV_2 $T=30 5800 0 0 $X=5 $Y=5795
X213 VDD VSS YSR 65 49 66 50 81 82 67 51 68 52 83 84 ICV_2 $T=20030 5800 0 0 $X=20005 $Y=5795
X214 VDD VSS YSR 78 53 69 54 85 86 70 55 71 56 87 88 ICV_2 $T=40030 5800 0 0 $X=40005 $Y=5795
X215 VDD VSS YSR 72 57 73 58 89 90 74 59 75 60 91 92 ICV_2 $T=60030 5800 0 0 $X=60005 $Y=5795
X216 WL4 VDD 61 62 VSS SRAM $T=20150 36155 0 0 $X=20125 $Y=36155
X217 WL1 VDD 61 62 VSS SRAM $T=20150 52475 0 0 $X=20125 $Y=52475
X218 WL1 VDD 63 64 VSS SRAM $T=25085 52475 0 0 $X=25060 $Y=52475
X219 WL4 VDD 63 64 VSS SRAM $T=25090 36155 0 0 $X=25065 $Y=36155
X220 WL7 VDD 74 75 VSS SRAM $T=57875 19835 0 0 $X=57850 $Y=19835
X221 WL5 VDD 74 75 VSS SRAM $T=57875 30715 0 0 $X=57850 $Y=30715
X222 WL3 VDD 74 75 VSS SRAM $T=57875 41595 0 0 $X=57850 $Y=41595
X223 WL6 VDD 74 75 VSS SRAM $T=57880 25275 0 0 $X=57855 $Y=25275
X224 WL4 VDD 74 75 VSS SRAM $T=57880 36155 0 0 $X=57855 $Y=36155
X225 WL2 VDD 74 75 VSS SRAM $T=57880 47030 0 0 $X=57855 $Y=47030
X226 WL1 VSS VDD WL0 74 75 ICV_3 $T=57875 52475 0 0 $X=57850 $Y=52475
X227 61 62 VDD PRE VSS Pre_charge_CKT $T=17940 15190 0 0 $X=17940 $Y=15190
X228 74 75 VDD PRE VSS Pre_charge_CKT $T=55670 15190 0 0 $X=55670 $Y=15190
X229 WL3 VSS VDD WL2 WL1 WL0 WL7 WL6 WL5 WL4 65 66 ICV_5 $T=30555 19835 0 0 $X=30525 $Y=19835
X230 WL3 VSS VDD WL2 WL1 WL0 WL7 WL6 WL5 WL4 67 68 ICV_5 $T=36020 19835 0 0 $X=35990 $Y=19835
X231 WL3 VSS VDD WL2 WL1 WL0 WL7 WL6 WL5 WL4 78 69 ICV_5 $T=41485 19835 0 0 $X=41455 $Y=19835
X232 WL3 VSS VDD WL2 WL1 WL0 WL7 WL6 WL5 WL4 70 71 ICV_5 $T=46950 19835 0 0 $X=46920 $Y=19835
X233 WL3 VSS VDD WL2 WL1 WL0 WL7 WL6 WL5 WL4 72 73 ICV_5 $T=52415 19835 0 0 $X=52385 $Y=19835
X234 VDD PRE VSS 63 64 65 66 ICV_6 $T=22880 15190 0 0 $X=22880 $Y=15190
X235 VDD PRE VSS 67 68 78 69 ICV_6 $T=33810 15190 0 0 $X=33810 $Y=15190
X236 VDD PRE VSS 70 71 72 73 ICV_6 $T=44740 15190 0 0 $X=44740 $Y=15190
X237 WL7 VSS VDD 61 62 63 64 ICV_7 $T=20150 19835 0 0 $X=20125 $Y=19835
X238 WL6 VSS VDD 61 62 63 64 ICV_7 $T=20150 25275 0 0 $X=20125 $Y=25275
X239 WL5 VSS VDD 61 62 63 64 ICV_7 $T=20150 30715 0 0 $X=20125 $Y=30715
X240 WL3 VSS VDD 61 62 63 64 ICV_7 $T=20150 41595 0 0 $X=20125 $Y=41595
X241 WL2 VSS VDD 61 62 63 64 ICV_7 $T=20150 47030 0 0 $X=20125 $Y=47030
X242 WL0 VSS VDD 61 62 63 64 ICV_7 $T=20155 57910 0 0 $X=20130 $Y=57910
X243 EN 4 26 5 6 VSS NAND_3IP $T=17760 25805 1 270 $X=13915 $Y=22365
X244 EN 42 28 5 6 VSS NAND_3IP $T=17765 31245 1 270 $X=13920 $Y=27805
X245 EN 4 32 43 6 VSS NAND_3IP $T=17765 36685 1 270 $X=13920 $Y=33245
X246 EN 42 30 43 6 VSS NAND_3IP $T=17765 42125 1 270 $X=13920 $Y=38685
X247 EN 4 34 5 44 VSS NAND_3IP $T=17765 47565 1 270 $X=13920 $Y=44125
X248 EN 42 36 5 44 VSS NAND_3IP $T=17765 53005 1 270 $X=13920 $Y=49565
X249 EN 4 38 43 44 VSS NAND_3IP $T=17765 58445 1 270 $X=13920 $Y=55005
X250 EN 42 40 43 44 VSS NAND_3IP $T=17765 63885 1 270 $X=13920 $Y=60445
.ENDS
***************************************
.SUBCKT subil_presistorpower 1 2
** N=3 EP=2 IP=0 FDC=1
R0 1 2 8253.06 L=1.46e-05 W=2.1e-06 $[RW] $X=-20 $Y=10560 $D=37
.ENDS
***************************************
.SUBCKT subil_pngatering_ESD22
** N=2 EP=0 IP=0 FDC=0
.ENDS
***************************************
.SUBCKT subil_pngatebuff_ESD22 2 3 4
** N=5 EP=3 IP=0 FDC=1
M0 2 3 4 2 N L=2.5e-07 W=3e-05 $X=26020 $Y=5400 $D=2
.ENDS
***************************************
.SUBCKT subil_pngate2buff_ESD22 2 3 4
** N=5 EP=3 IP=10 FDC=2
X0 2 3 4 subil_pngatebuff_ESD22 $T=0 6220 1 0 $X=16000 $Y=-2070
X1 2 3 4 subil_pngatebuff_ESD22 $T=0 2640 0 0 $X=16000 $Y=1430
.ENDS
***************************************
.SUBCKT ICV_8 2 3 4
** N=5 EP=3 IP=10 FDC=4
X0 2 3 4 subil_pngate2buff_ESD22 $T=0 -9440 0 0 $X=16000 $Y=-11510
X1 2 3 4 subil_pngate2buff_ESD22 $T=0 0 0 0 $X=16000 $Y=-2070
.ENDS
***************************************
.SUBCKT subil_4via_ESD
** N=2 EP=0 IP=0 FDC=0
.ENDS
***************************************
.SUBCKT subil_pv0icon_ESD
** N=5 EP=0 IP=12 FDC=0
.ENDS
***************************************
.SUBCKT subil_ppgatebuffpower_0di_ESD22 1 2 3
** N=5 EP=3 IP=0 FDC=1
M0 2 3 1 2 P L=2.5e-07 W=4e-05 $X=9010 $Y=4310 $D=6
.ENDS
***************************************
.SUBCKT subil_ppgate2buffpower_0di_ESD22 1 2 3
** N=5 EP=3 IP=10 FDC=2
X0 1 2 3 subil_ppgatebuffpower_0di_ESD22 $T=0 3020 1 0 $X=3710 $Y=-4550
X1 1 2 3 subil_ppgatebuffpower_0di_ESD22 $T=0 -560 0 0 $X=3710 $Y=-1860
.ENDS
***************************************
.SUBCKT subil_ppbuffpower_0di_ESD22 1 2 3
** N=5 EP=3 IP=30 FDC=12
X0 1 2 3 subil_ppgate2buffpower_0di_ESD22 $T=0 1030 0 0 $X=3710 $Y=-3520
X1 1 2 3 subil_ppgate2buffpower_0di_ESD22 $T=0 8290 0 0 $X=3710 $Y=3740
X2 1 2 3 subil_ppgate2buffpower_0di_ESD22 $T=0 15550 0 0 $X=3710 $Y=11000
X3 1 2 3 subil_ppgate2buffpower_0di_ESD22 $T=0 22810 0 0 $X=3710 $Y=18260
X4 1 2 3 subil_ppgate2buffpower_0di_ESD22 $T=0 30070 0 0 $X=3710 $Y=25520
X5 1 2 3 subil_ppgate2buffpower_0di_ESD22 $T=0 37330 0 0 $X=3710 $Y=32780
.ENDS
***************************************
.SUBCKT subil_pdiodepower
** N=2 EP=0 IP=0 FDC=0
.ENDS
***************************************
.SUBCKT subil_powerbase_1 1 2 3 4
** N=9 EP=4 IP=4 FDC=19
D0 4 1 P3 AREA=1.331e-11 PJ=2.862e-05 $X=14620 $Y=11030 $D=54
D1 4 1 P3 AREA=1.331e-11 PJ=2.862e-05 $X=17420 $Y=11030 $D=54
D2 4 1 P3 AREA=1.331e-11 PJ=2.862e-05 $X=20220 $Y=11030 $D=54
D3 4 1 P3 AREA=1.331e-11 PJ=2.862e-05 $X=23020 $Y=11030 $D=54
D4 4 1 P3 AREA=1.331e-11 PJ=2.862e-05 $X=25820 $Y=11030 $D=54
D5 4 1 P3 AREA=1.331e-11 PJ=2.862e-05 $X=28620 $Y=11030 $D=54
D6 4 1 P3 AREA=1.331e-11 PJ=2.862e-05 $X=31420 $Y=11030 $D=54
D7 4 1 P3 AREA=1.331e-11 PJ=2.862e-05 $X=34220 $Y=11030 $D=54
D8 4 1 P3 AREA=1.331e-11 PJ=2.862e-05 $X=37020 $Y=11030 $D=54
D9 1 4 P3 AREA=1.331e-11 PJ=2.862e-05 $X=43960 $Y=11030 $D=54
D10 1 4 P3 AREA=1.331e-11 PJ=2.862e-05 $X=46760 $Y=11030 $D=54
D11 1 4 P3 AREA=1.331e-11 PJ=2.862e-05 $X=49560 $Y=11030 $D=54
D12 1 4 P3 AREA=1.331e-11 PJ=2.862e-05 $X=52360 $Y=11030 $D=54
D13 1 4 P3 AREA=1.331e-11 PJ=2.862e-05 $X=55160 $Y=11030 $D=54
D14 1 4 P3 AREA=1.331e-11 PJ=2.862e-05 $X=57960 $Y=11030 $D=54
D15 1 4 P3 AREA=1.331e-11 PJ=2.862e-05 $X=60760 $Y=11030 $D=54
D16 1 4 P3 AREA=1.331e-11 PJ=2.862e-05 $X=63560 $Y=11030 $D=54
D17 1 4 P3 AREA=1.331e-11 PJ=2.862e-05 $X=66360 $Y=11030 $D=54
C18 3 2 L=1.513e-05 W=1.513e-05 $[CH] $X=51860 $Y=41355 $D=61
.ENDS
***************************************
.SUBCKT pv0i VDD VSS VSSO
** N=10 EP=3 IP=57 FDC=47
*.CALIBRE ISOLATED NETS: VDDO
X1 VDD 6 subil_presistorpower $T=3010 196210 0 0 $X=2810 $Y=205700
X2 6 8 subil_presistorpower $T=3010 216270 0 0 $X=2810 $Y=225760
X3 7 9 subil_presistorpower $T=60150 196210 0 0 $X=59950 $Y=205700
X4 9 VSS subil_presistorpower $T=60150 216270 0 0 $X=59950 $Y=225760
X7 VSS 7 VDD subil_pngate2buff_ESD22 $T=13340 151690 1 270 $X=2410 $Y=87580
X8 VSS 7 VDD subil_pngate2buff_ESD22 $T=60540 151690 1 270 $X=49610 $Y=87580
X9 VSS 7 VDD ICV_8 $T=22780 151690 1 270 $X=11850 $Y=87580
X10 VSS 7 VDD ICV_8 $T=41660 151690 1 270 $X=30730 $Y=87580
X12 VSS VDD 8 subil_ppbuffpower_0di_ESD22 $T=3500 203800 0 0 $X=-60 $Y=196810
X13 VSS 7 VDD VSSO subil_powerbase_1 $T=-8490 129540 0 0 $X=-325 $Y=129540
.ENDS
***************************************
.SUBCKT subil_pngatering
** N=5 EP=0 IP=0 FDC=0
.ENDS
***************************************
.SUBCKT subil_pngatebuff_ESD 1 2 3
** N=6 EP=3 IP=0 FDC=1
M0 2 3 1 2 NH L=4e-07 W=3e-05 $X=26020 $Y=5250 $D=1
.ENDS
***************************************
.SUBCKT subil_pngate2buff_ESD 1 2 3
** N=6 EP=3 IP=12 FDC=2
X0 1 2 3 subil_pngatebuff_ESD $T=0 6220 1 0 $X=16000 $Y=-2070
X1 1 2 3 subil_pngatebuff_ESD $T=0 2640 0 0 $X=16000 $Y=1330
.ENDS
***************************************
.SUBCKT ICV_9 1 2 3
** N=6 EP=3 IP=12 FDC=4
X0 2 3 1 subil_pngate2buff_ESD $T=0 -9440 0 0 $X=16000 $Y=-11510
X1 2 3 1 subil_pngate2buff_ESD $T=0 0 0 0 $X=16000 $Y=-2070
.ENDS
***************************************
.SUBCKT subil_pv0acon_ESD
** N=5 EP=0 IP=12 FDC=0
.ENDS
***************************************
.SUBCKT subil_ppgatebuffpower 2 3 4
** N=6 EP=3 IP=0 FDC=1
M0 2 3 4 2 PH L=4e-07 W=4e-05 $X=9010 $Y=4110 $D=8
.ENDS
***************************************
.SUBCKT subil_ppgate2buffpower 2 3 4
** N=6 EP=3 IP=12 FDC=2
X0 2 3 4 subil_ppgatebuffpower $T=0 3020 1 0 $X=-3870 $Y=-4910
X1 2 3 4 subil_ppgatebuffpower $T=0 -560 0 0 $X=-3870 $Y=-1870
.ENDS
***************************************
.SUBCKT subil_ppbuffpower 2 3 4
** N=6 EP=3 IP=36 FDC=12
X0 2 3 4 subil_ppgate2buffpower $T=0 1030 0 0 $X=-3870 $Y=-3880
X1 2 3 4 subil_ppgate2buffpower $T=0 8290 0 0 $X=-3870 $Y=3380
X2 2 3 4 subil_ppgate2buffpower $T=0 15550 0 0 $X=-3870 $Y=10640
X3 2 3 4 subil_ppgate2buffpower $T=0 22810 0 0 $X=-3870 $Y=17900
X4 2 3 4 subil_ppgate2buffpower $T=0 30070 0 0 $X=-3870 $Y=25160
X5 2 3 4 subil_ppgate2buffpower $T=0 37330 0 0 $X=-3870 $Y=32420
.ENDS
***************************************
.SUBCKT pv0a VDDO VSSO VSS
** N=10 EP=3 IP=68 FDC=47
*.CALIBRE ISOLATED NETS: VDD
X1 VDDO 7 subil_presistorpower $T=3010 196210 0 0 $X=2810 $Y=205700
X2 7 8 subil_presistorpower $T=3010 216270 0 0 $X=2810 $Y=225760
X3 6 9 subil_presistorpower $T=60150 196210 0 0 $X=59950 $Y=205700
X4 9 VSSO subil_presistorpower $T=60150 216270 0 0 $X=59950 $Y=225760
X5 VSS 6 VDDO VSSO subil_powerbase_1 $T=-8490 129540 0 0 $X=-325 $Y=129540
X8 VDDO VSSO 6 subil_pngate2buff_ESD $T=13340 151690 1 270 $X=2410 $Y=87580
X9 VDDO VSSO 6 subil_pngate2buff_ESD $T=60540 151690 1 270 $X=49610 $Y=87580
X10 6 VDDO VSSO ICV_9 $T=22780 151690 1 270 $X=11850 $Y=87580
X11 6 VDDO VSSO ICV_9 $T=41660 151690 1 270 $X=30730 $Y=87580
X13 VDDO 8 VSSO subil_ppbuffpower $T=3500 203800 0 0 $X=-370 $Y=196810
.ENDS
***************************************
.SUBCKT subil_pngatebuff_ESD1 1 2 3
** N=6 EP=3 IP=0 FDC=1
M0 2 3 1 2 NH L=4e-07 W=3e-05 $X=26020 $Y=5250 $D=1
.ENDS
***************************************
.SUBCKT subil_pngate2buff_ESD1 1 2 3
** N=6 EP=3 IP=12 FDC=2
X0 1 2 3 subil_pngatebuff_ESD1 $T=0 6220 1 0 $X=16000 $Y=-2070
X1 1 2 3 subil_pngatebuff_ESD1 $T=0 2640 0 0 $X=16000 $Y=1080
.ENDS
***************************************
.SUBCKT subil_pvdacon_ESD
** N=5 EP=0 IP=0 FDC=0
.ENDS
***************************************
.SUBCKT subil_powerbasecon_ESD 1 2 3 4
** N=11 EP=4 IP=12 FDC=4
X0 3 10 subil_presistorpower $T=1110 -9670 0 0 $X=910 $Y=-180
X1 10 2 subil_presistorpower $T=1110 10390 0 0 $X=910 $Y=19880
X2 1 11 subil_presistorpower $T=56330 -9550 0 0 $X=56130 $Y=-60
X3 11 4 subil_presistorpower $T=56330 10510 0 0 $X=56130 $Y=20000
.ENDS
***************************************
.SUBCKT pvda VSS VSSO VDDO
** N=9 EP=3 IP=77 FDC=47
*.CALIBRE ISOLATED NETS: VDD
X1 VSS 6 VDDO VSSO subil_powerbase_1 $T=-8490 129540 0 0 $X=-325 $Y=129540
X4 VDDO 7 VSSO subil_ppbuffpower $T=3500 203800 0 0 $X=-370 $Y=196810
X5 VDDO VSSO 6 subil_pngate2buff_ESD1 $T=13340 151690 1 270 $X=2410 $Y=87580
X6 VDDO VSSO 6 subil_pngate2buff_ESD1 $T=22780 151690 1 270 $X=11850 $Y=87580
X7 VDDO VSSO 6 subil_pngate2buff_ESD1 $T=32220 151690 1 270 $X=21290 $Y=87580
X8 VDDO VSSO 6 subil_pngate2buff_ESD1 $T=41660 151690 1 270 $X=30730 $Y=87580
X9 VDDO VSSO 6 subil_pngate2buff_ESD1 $T=51100 151690 1 270 $X=40170 $Y=87580
X10 VDDO VSSO 6 subil_pngate2buff_ESD1 $T=60540 151690 1 270 $X=49610 $Y=87580
X12 6 7 VDDO VSSO subil_powerbasecon_ESD $T=3330 205880 0 0 $X=4240 $Y=126110
.ENDS
***************************************
.SUBCKT subil_pngatering22
** N=4 EP=0 IP=0 FDC=0
.ENDS
***************************************
.SUBCKT subil_pvdicon_ESD
** N=6 EP=0 IP=0 FDC=0
.ENDS
***************************************
.SUBCKT subil_pngatebuff_ESD122 2 3 4
** N=7 EP=3 IP=0 FDC=1
M0 2 3 4 2 N L=2.5e-07 W=3e-05 $X=26020 $Y=5400 $D=2
.ENDS
***************************************
.SUBCKT subil_pngate2buff_ESD122 2 3 4
** N=7 EP=3 IP=14 FDC=2
X0 2 3 4 subil_pngatebuff_ESD122 $T=0 6220 1 0 $X=16000 $Y=-2070
X1 2 3 4 subil_pngatebuff_ESD122 $T=0 2640 0 0 $X=16000 $Y=1080
.ENDS
***************************************
.SUBCKT pvdi VDD VSS VSSO
** N=9 EP=3 IP=81 FDC=47
*.CALIBRE ISOLATED NETS: VDDO
X1 VSS VDD 7 subil_ppbuffpower_0di_ESD22 $T=3500 203800 0 0 $X=-60 $Y=196810
X2 VSS 6 VDD VSSO subil_powerbase_1 $T=-8490 129540 0 0 $X=-325 $Y=129540
X3 6 7 VDD VSS subil_powerbasecon_ESD $T=3330 205880 0 0 $X=4240 $Y=126110
X7 VSSO 6 VDD subil_pngate2buff_ESD122 $T=13340 151690 1 270 $X=2410 $Y=87580
X8 VSSO 6 VDD subil_pngate2buff_ESD122 $T=22780 151690 1 270 $X=11850 $Y=87580
X9 VSSO 6 VDD subil_pngate2buff_ESD122 $T=32220 151690 1 270 $X=21290 $Y=87580
X10 VSSO 6 VDD subil_pngate2buff_ESD122 $T=41660 151690 1 270 $X=30730 $Y=87580
X11 VSSO 6 VDD subil_pngate2buff_ESD122 $T=51100 151690 1 270 $X=40170 $Y=87580
X12 VSSO 6 VDD subil_pngate2buff_ESD122 $T=60540 151690 1 270 $X=49610 $Y=87580
.ENDS
***************************************
.SUBCKT SRAM_CHIP
** N=36322 EP=0 IP=465 FDC=2094
X36 1309 8444 8443 17062 pc3d00 $T=335090 1611850 0 270 $X=335090 $Y=1545930
X37 1351 8444 8443 17062 pc3d00 $T=335090 1706850 0 270 $X=335090 $Y=1640930
X38 1276 8444 8443 17062 pc3d00 $T=335090 1801850 0 270 $X=335090 $Y=1735930
X39 1349 8444 8443 17062 pc3d00 $T=335090 1896850 0 270 $X=335090 $Y=1830930
X40 1255 8444 8443 17062 pc3d00 $T=335090 1991850 0 270 $X=335090 $Y=1925930
X41 1649 8444 8443 17062 pc3d00 $T=335090 2086850 0 270 $X=335090 $Y=2020930
X42 1550 8444 8443 17062 pc3d00 $T=335090 2181850 0 270 $X=335090 $Y=2115930
X43 1033 8444 8443 17062 pc3d00 $T=335090 2276850 0 270 $X=335090 $Y=2210930
X44 13298 8444 8443 17062 pc3d00 $T=995090 1266850 0 0 $X=994170 $Y=1266850
X45 13453 8444 8443 17062 pc3d00 $T=1060090 2556850 0 180 $X=994170 $Y=2306530
X46 13778 8444 8443 17062 pc3d00 $T=1090090 1266850 0 0 $X=1089170 $Y=1266850
X47 13884 8444 8443 17062 pc3d00 $T=1155090 2556850 0 180 $X=1089170 $Y=2306530
X48 14636 8444 8443 17062 pc3d00 $T=1185090 1266850 0 0 $X=1184170 $Y=1266850
X49 14757 8444 8443 17062 pc3d00 $T=1250090 2556850 0 180 $X=1184170 $Y=2306530
X50 15395 8444 8443 17062 pc3d00 $T=1280090 1266850 0 0 $X=1279170 $Y=1266850
X51 17063 8444 8443 17062 pc3d00 $T=1345090 2556850 0 180 $X=1279170 $Y=2306530
X52 7436 8444 8443 17062 pc3d00 $T=1625090 1611850 1 270 $X=1374770 $Y=1545930
X53 7408 8444 8443 17062 pc3d00 $T=1625090 1706850 1 270 $X=1374770 $Y=1640930
X54 7420 8444 8443 17062 pc3d00 $T=1625090 1801850 1 270 $X=1374770 $Y=1735930
X55 7434 8444 8443 17062 pc3d00 $T=1625090 1831850 0 90 $X=1374770 $Y=1830930
X56 7402 8444 8443 17062 pc3d00 $T=1625090 1926850 0 90 $X=1374770 $Y=1925930
X57 7401 8444 8443 17062 pc3d00 $T=1625090 2021850 0 90 $X=1374770 $Y=2020930
X58 7324 8444 8443 17062 pc3d00 $T=1625090 2116850 0 90 $X=1374770 $Y=2115930
X59 7224 8444 8443 17062 pc3d00 $T=1625090 2211850 0 90 $X=1374770 $Y=2210930
X84 9886 14757 8444 14636 13778 13298 1309 1351 1276 1349 1255 1649 1550 1033 13453 15395 13884 7436 7408 7420
+ 7434 7402 7401 7324 7224
+ 6TSRAM_ARRAY $T=1061995 1903915 0 90 $X=990900 $Y=1903915
X85 9886 8444 17062 pv0i $T=710090 2556850 1 0 $X=709220 $Y=2306790
X86 9886 8444 17062 pv0i $T=900090 2556850 1 0 $X=899220 $Y=2306790
X87 8443 17062 8444 pv0a $T=710090 1266850 0 0 $X=709220 $Y=1266850
X88 8443 17062 8444 pv0a $T=900090 1266850 0 0 $X=899220 $Y=1266850
X89 8444 17062 8443 pvda $T=615090 2556850 1 0 $X=614220 $Y=2306530
X90 8444 17062 8443 pvda $T=805090 2556850 1 0 $X=804220 $Y=2306530
X91 9886 8444 17062 pvdi $T=615090 1266850 0 0 $X=614220 $Y=1266850
X92 9886 8444 17062 pvdi $T=805090 1266850 0 0 $X=804220 $Y=1266850
.ENDS
***************************************
