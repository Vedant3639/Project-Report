* SPICE NETLIST
***************************************

.SUBCKT M2_M1_S_CDNS_783179060153
** N=1 EP=0 IP=0 FDC=0
.ENDS
***************************************
.SUBCKT M2_M1_S_CDNS_783179060151
** N=1 EP=0 IP=0 FDC=0
.ENDS
***************************************
.SUBCKT ML_M3_S_CDNS_7831790601521
** N=2 EP=0 IP=0 FDC=0
.ENDS
***************************************
.SUBCKT nmos_18_CDNS_783179060150 1 2 3 4
** N=4 EP=4 IP=0 FDC=1
M0 2 3 1 4 N L=1.8e-07 W=4.2e-07 $X=480 $Y=0 $D=2
.ENDS
***************************************
.SUBCKT pmos_18_CDNS_783179060151 1 2 3 4
** N=4 EP=4 IP=0 FDC=1
M0 2 3 1 4 P L=1.8e-07 W=4.2e-07 $X=480 $Y=0 $D=6
.ENDS
***************************************
.SUBCKT M1_PO_4X_CDNS_7831790601512
** N=2 EP=0 IP=0 FDC=0
.ENDS
***************************************
.SUBCKT M2_M1_S_CDNS_7831790601511
** N=2 EP=0 IP=0 FDC=0
.ENDS
***************************************
.SUBCKT ICV_1
** N=2 EP=0 IP=4 FDC=0
.ENDS
***************************************
.SUBCKT ColumnMux YSR BLB BL YSR_BAR
** N=10 EP=4 IP=66 FDC=10
X12 4 BLB YSR 2 nmos_18_CDNS_783179060150 $T=1570 2455 1 180 $X=250 $Y=2105
X13 BL 7 YSR 2 nmos_18_CDNS_783179060150 $T=3570 2455 1 180 $X=2250 $Y=2105
X14 BLB 8 YSR_BAR 2 nmos_18_CDNS_783179060150 $T=5570 2455 1 180 $X=4250 $Y=2105
X15 9 BL YSR_BAR 2 nmos_18_CDNS_783179060150 $T=7070 2455 1 180 $X=5750 $Y=2105
X16 2 YSR_BAR YSR 2 nmos_18_CDNS_783179060150 $T=7930 2450 0 0 $X=7750 $Y=2100
X17 4 BLB YSR_BAR 3 pmos_18_CDNS_783179060151 $T=1570 3735 1 180 $X=0 $Y=3305
X18 BL 7 YSR_BAR 3 pmos_18_CDNS_783179060151 $T=3570 3735 1 180 $X=2000 $Y=3305
X19 BLB 8 YSR 3 pmos_18_CDNS_783179060151 $T=5570 3735 1 180 $X=4000 $Y=3305
X20 9 BL YSR 3 pmos_18_CDNS_783179060151 $T=7070 3735 1 180 $X=5500 $Y=3305
X21 3 YSR_BAR YSR 3 pmos_18_CDNS_783179060151 $T=7930 3735 0 0 $X=7500 $Y=3305
.ENDS
***************************************
