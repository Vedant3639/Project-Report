* SPICE NETLIST
***************************************

.SUBCKT M3_M2_S_CDNS_784376149448
** N=2 EP=0 IP=0 FDC=0
.ENDS
***************************************
.SUBCKT M3_M2_S_CDNS_784376149444
** N=2 EP=0 IP=0 FDC=0
.ENDS
***************************************
.SUBCKT pmos_18_CDNS_784376149441 1 2 3 4
** N=4 EP=4 IP=0 FDC=1
M0 2 3 1 4 P L=1.8e-07 W=4.2e-07 $X=480 $Y=0 $D=6
.ENDS
***************************************
.SUBCKT nmos_18_CDNS_784376149440 1 2 3 4
** N=4 EP=4 IP=0 FDC=1
M0 2 3 1 4 N L=1.8e-07 W=4.2e-07 $X=480 $Y=0 $D=2
.ENDS
***************************************
.SUBCKT ML_M3_S_CDNS_7843761494419
** N=1 EP=0 IP=0 FDC=0
.ENDS
***************************************
.SUBCKT M3_M2_S_CDNS_7843761494417
** N=1 EP=0 IP=0 FDC=0
.ENDS
***************************************
.SUBCKT CMOS_inv VIN VDD OUT VSS
** N=4 EP=4 IP=10 FDC=2
X0 VDD OUT VIN VDD pmos_18_CDNS_784376149441 $T=430 1640 0 0 $X=0 $Y=1210
X1 VSS OUT VIN VSS nmos_18_CDNS_784376149440 $T=430 350 0 0 $X=250 $Y=0
.ENDS
***************************************
.SUBCKT M2_M1_S_CDNS_784376149443
** N=1 EP=0 IP=0 FDC=0
.ENDS
***************************************
.SUBCKT Write_Driver 1 WD_BL WD_BLB 4
** N=6 EP=4 IP=13 FDC=6
X0 5 1 WD_BL 4 CMOS_inv $T=25 1570 0 0 $X=0 $Y=845
X1 DIN 1 WD_BLB 4 CMOS_inv $T=2025 1570 0 0 $X=2000 $Y=845
X2 DIN 1 5 4 CMOS_inv $T=4025 1570 0 0 $X=4000 $Y=845
.ENDS
***************************************
.SUBCKT M3_M2_S_CDNS_784376149440
** N=1 EP=0 IP=0 FDC=0
.ENDS
***************************************
.SUBCKT M2_M1_S_CDNS_7843761494425
** N=1 EP=0 IP=0 FDC=0
.ENDS
***************************************
.SUBCKT M3_M2_S_CDNS_7843761494426
** N=2 EP=0 IP=0 FDC=0
.ENDS
***************************************
.SUBCKT M2_M1_S_CDNS_7843761494427
** N=1 EP=0 IP=0 FDC=0
.ENDS
***************************************
.SUBCKT pmos_18_CDNS_784376149443 1 2 3
** N=3 EP=3 IP=0 FDC=1
M0 2 3 1 1 P L=1.8e-07 W=4.2e-07 $X=480 $Y=0 $D=6
.ENDS
***************************************
.SUBCKT Diff_Sense_Amp SE 2 3 4 VDD
** N=8 EP=5 IP=15 FDC=5
M0 7 2 6 4 N L=1.8e-07 W=4.2e-07 $X=2625 $Y=1300 $D=2
M1 VOUT 3 7 4 N L=1.8e-07 W=4.2e-07 $X=3345 $Y=1300 $D=2
M2 VOUT 6 VDD VDD P L=1.8e-07 W=4.2e-07 $X=3345 $Y=2840 $D=6
X3 4 7 SE 4 nmos_18_CDNS_784376149440 $T=645 1300 0 0 $X=465 $Y=950
X11 VDD 6 6 pmos_18_CDNS_784376149443 $T=3285 2840 1 180 $X=1715 $Y=2410
.ENDS
***************************************
.SUBCKT M3_M2_S_CDNS_7843761494431
** N=1 EP=0 IP=0 FDC=0
.ENDS
***************************************
.SUBCKT M2_M1_S_CDNS_784376149441
** N=1 EP=0 IP=0 FDC=0
.ENDS
***************************************
.SUBCKT Column_Mux 1 BL SA_BL BLB SA_BLB WD_BL WD_BLB 8 9
** N=10 EP=9 IP=59 FDC=10
X0 BL SA_BL 1 8 pmos_18_CDNS_784376149441 $T=2430 3560 0 0 $X=2000 $Y=3130
X1 BLB SA_BLB 1 8 pmos_18_CDNS_784376149441 $T=4430 3560 0 0 $X=4000 $Y=3130
X2 BL WD_BL 10 8 pmos_18_CDNS_784376149441 $T=6430 3560 0 0 $X=6000 $Y=3130
X3 BLB WD_BLB 10 8 pmos_18_CDNS_784376149441 $T=8430 3560 0 0 $X=8000 $Y=3130
X4 SA_BL BL 10 9 nmos_18_CDNS_784376149440 $T=3565 2270 1 180 $X=2245 $Y=1920
X5 SA_BLB BLB 10 9 nmos_18_CDNS_784376149440 $T=5575 2270 1 180 $X=4255 $Y=1920
X6 WD_BL BL 1 9 nmos_18_CDNS_784376149440 $T=7570 2270 1 180 $X=6250 $Y=1920
X7 WD_BLB BLB 1 9 nmos_18_CDNS_784376149440 $T=9570 2270 1 180 $X=8250 $Y=1920
X8 1 8 10 9 CMOS_inv $T=0 1920 0 0 $X=-25 $Y=1195
.ENDS
***************************************
.SUBCKT ICV_1 1 2 3 4 5 6 7 8 9 10 11 12 13 14 15
** N=15 EP=15 IP=18 FDC=20
X0 3 4 5 6 7 8 9 1 2 Column_Mux $T=0 0 0 0 $X=-25 $Y=-5
X1 3 10 11 12 13 14 15 1 2 Column_Mux $T=10000 0 0 0 $X=9975 $Y=-5
.ENDS
***************************************
.SUBCKT pmos_18_CDNS_784376149447 1 2 3
** N=3 EP=3 IP=0 FDC=1
M0 2 3 1 1 P L=1.8e-07 W=2.2e-07 $X=420 $Y=0 $D=6
.ENDS
***************************************
.SUBCKT nmos_18_CDNS_784376149448 1 2 3 4
** N=4 EP=4 IP=0 FDC=1
M0 2 3 1 4 N L=1.8e-07 W=2.2e-07 $X=420 $Y=0 $D=2
.ENDS
***************************************
.SUBCKT nmos_18_CDNS_784376149446 1 2 3 4
** N=4 EP=4 IP=0 FDC=1
M0 2 3 1 4 N L=1.8e-07 W=4.4e-07 $X=480 $Y=0 $D=2
.ENDS
***************************************
.SUBCKT M3_M2_S_CDNS_7843761494422
** N=2 EP=0 IP=0 FDC=0
.ENDS
***************************************
.SUBCKT M2_M1_S_CDNS_7843761494423
** N=2 EP=0 IP=0 FDC=0
.ENDS
***************************************
.SUBCKT SRAM WL VDD BL BLB VSS 6
** N=8 EP=6 IP=35 FDC=6
X4 VDD 8 7 pmos_18_CDNS_784376149447 $T=2040 4110 1 180 $X=490 $Y=3580
X5 VDD 7 8 pmos_18_CDNS_784376149447 $T=2600 4110 0 0 $X=2070 $Y=3580
X6 BL 8 WL 6 nmos_18_CDNS_784376149448 $T=1280 660 0 90 $X=610 $Y=380
X7 7 BLB WL 6 nmos_18_CDNS_784376149448 $T=3620 1680 1 270 $X=2950 $Y=380
X8 VSS 8 7 6 nmos_18_CDNS_784376149446 $T=2100 2310 1 180 $X=780 $Y=1960
X9 VSS 7 8 6 nmos_18_CDNS_784376149446 $T=2540 2310 0 0 $X=2360 $Y=1960
.ENDS
***************************************
.SUBCKT ICV_2 1 2 3 4 5 6 7 8
** N=8 EP=8 IP=12 FDC=12
X0 1 4 6 7 3 8 SRAM $T=0 0 0 0 $X=-25 $Y=0
X1 2 4 6 7 5 8 SRAM $T=0 5440 0 0 $X=-25 $Y=5440
.ENDS
***************************************
.SUBCKT ICV_3 1 2 3 4 5 6 7 8 9 10 11 12
** N=12 EP=12 IP=20 FDC=24
X0 1 6 10 11 5 12 SRAM $T=0 10880 0 0 $X=-25 $Y=10880
X1 2 6 10 11 7 12 SRAM $T=0 16340 0 0 $X=-25 $Y=16340
X2 4 3 8 6 9 10 11 12 ICV_2 $T=0 0 0 0 $X=-25 $Y=0
.ENDS
***************************************
.SUBCKT ICV_4 1 2 3 4 5 6 7 8
** N=8 EP=8 IP=12 FDC=12
X0 1 4 6 7 3 8 SRAM $T=0 0 0 0 $X=-25 $Y=0
X1 2 4 6 7 5 8 SRAM $T=0 5435 0 0 $X=-25 $Y=5435
.ENDS
***************************************
.SUBCKT ICV_5 1 2 3 4 5 6 7 8 9 10 11 12
** N=12 EP=12 IP=16 FDC=24
X0 1 2 6 5 7 10 11 12 ICV_4 $T=0 0 0 0 $X=-25 $Y=0
X1 3 4 8 5 9 10 11 12 ICV_4 $T=0 10880 0 0 $X=-25 $Y=10880
.ENDS
***************************************
.SUBCKT ICV_6 1 2 3 4 5 6 7 8 9 10 11 12 13 14 15 16 17 18 19 20
** N=20 EP=20 IP=24 FDC=48
X0 3 2 1 4 12 9 13 10 11 18 19 20 ICV_3 $T=0 0 0 0 $X=-25 $Y=0
X1 5 8 7 6 9 14 15 16 17 18 19 20 ICV_5 $T=0 21760 0 0 $X=-25 $Y=21760
.ENDS
***************************************
.SUBCKT M3_M2_S_CDNS_7843761494429
** N=2 EP=0 IP=0 FDC=0
.ENDS
***************************************
.SUBCKT Pre_charge_CKT BL BLB 3 4 5
** N=6 EP=5 IP=14 FDC=5
M0 BLB 6 BL 3 P L=1.8e-07 W=4.2e-07 $X=3655 $Y=2365 $D=6
M1 3 6 BLB 3 P L=1.8e-07 W=4.2e-07 $X=4375 $Y=2365 $D=6
X2 3 BL 6 3 pmos_18_CDNS_784376149441 $T=2455 2785 1 0 $X=2025 $Y=1935
X4 4 3 6 5 CMOS_inv $T=25 725 0 0 $X=0 $Y=0
.ENDS
***************************************
.SUBCKT ICV_7 1 2 3 4 5 6 7
** N=7 EP=7 IP=10 FDC=10
X0 4 5 1 2 3 Pre_charge_CKT $T=0 0 0 0 $X=0 $Y=0
X1 6 7 1 2 3 Pre_charge_CKT $T=5465 0 0 0 $X=5465 $Y=0
.ENDS
***************************************
.SUBCKT ICV_8 1 2 3 4 5 6 7 8
** N=8 EP=8 IP=12 FDC=12
X0 1 3 4 5 2 8 SRAM $T=0 0 0 0 $X=-25 $Y=0
X1 1 3 6 7 2 8 SRAM $T=4950 0 0 0 $X=4925 $Y=0
.ENDS
***************************************
.SUBCKT nmos_18_CDNS_784376149442 1 2 3 4
** N=4 EP=4 IP=0 FDC=1
M0 2 3 1 4 N L=1.8e-07 W=4.2e-07 $X=480 $Y=0 $D=2
.ENDS
***************************************
.SUBCKT NAND_3IP 1 C Y B A VSS
** N=8 EP=6 IP=20 FDC=6
M0 Y C 1 1 P L=1.8e-07 W=4.2e-07 $X=910 $Y=1640 $D=6
M1 1 B Y 1 P L=1.8e-07 W=4.2e-07 $X=1630 $Y=1640 $D=6
X7 1 Y A pmos_18_CDNS_784376149443 $T=1870 1640 0 0 $X=1540 $Y=1210
X8 VSS 7 C VSS nmos_18_CDNS_784376149442 $T=430 350 0 0 $X=250 $Y=0
X9 7 8 B VSS nmos_18_CDNS_784376149442 $T=1150 350 0 0 $X=970 $Y=0
X10 8 Y A VSS nmos_18_CDNS_784376149442 $T=1870 350 0 0 $X=1690 $Y=0
.ENDS
***************************************
.SUBCKT SRAM_ARRAY_PG VDD EN VSS WL3 WL0 WL4 WL2 WL1 WL6 WL5 WL7 PRE YSR SE
** N=84 EP=14 IP=697 FDC=670
X4 VSS 12 WL7 VSS nmos_18_CDNS_784376149440 $T=64495 21640 0 90 $X=63725 $Y=21460
X5 VSS 13 WL6 VSS nmos_18_CDNS_784376149440 $T=64495 27080 0 90 $X=63725 $Y=26900
X6 VSS 14 WL5 VSS nmos_18_CDNS_784376149440 $T=64495 32520 0 90 $X=63725 $Y=32340
X7 VSS 15 WL4 VSS nmos_18_CDNS_784376149440 $T=64495 37980 0 90 $X=63725 $Y=37800
X8 VSS 16 WL3 VSS nmos_18_CDNS_784376149440 $T=64495 43400 0 90 $X=63725 $Y=43220
X9 VSS 17 WL2 VSS nmos_18_CDNS_784376149440 $T=64495 48835 0 90 $X=63725 $Y=48655
X10 VSS 18 WL1 VSS nmos_18_CDNS_784376149440 $T=64495 54280 0 90 $X=63725 $Y=54100
X11 VSS 19 WL0 VSS nmos_18_CDNS_784376149440 $T=64495 59715 0 90 $X=63725 $Y=59535
X12 20 EN WL7 VSS CMOS_inv $T=19530 23570 1 270 $X=16610 $Y=21570
X13 21 EN WL6 VSS CMOS_inv $T=19530 29010 1 270 $X=16610 $Y=27010
X14 22 EN WL4 VSS CMOS_inv $T=19530 39890 1 270 $X=16610 $Y=37890
X15 23 EN WL5 VSS CMOS_inv $T=19535 34450 1 270 $X=16615 $Y=32450
X16 24 EN WL3 VSS CMOS_inv $T=19535 45330 1 270 $X=16615 $Y=43330
X17 25 EN WL2 VSS CMOS_inv $T=19535 50770 1 270 $X=16615 $Y=48770
X18 26 EN WL1 VSS CMOS_inv $T=19535 56210 1 270 $X=16615 $Y=54210
X19 27 EN WL0 VSS CMOS_inv $T=19535 61650 1 270 $X=16615 $Y=59650
X20 28 EN 29 VSS CMOS_inv $T=19535 67090 1 270 $X=16615 $Y=65090
X21 30 EN 31 VSS CMOS_inv $T=19535 69090 1 270 $X=16615 $Y=67090
X22 32 EN 33 VSS CMOS_inv $T=19535 71090 1 270 $X=16615 $Y=69090
X89 VDD 68 69 VSS Write_Driver $T=7725 1205 0 0 $X=7725 $Y=1205
X90 VDD 71 72 VSS Write_Driver $T=17725 1205 0 0 $X=17725 $Y=1205
X91 VDD 73 74 VSS Write_Driver $T=27725 1205 0 0 $X=27725 $Y=1205
X92 VDD 75 76 VSS Write_Driver $T=37725 1205 0 0 $X=37725 $Y=1205
X93 VDD 77 78 VSS Write_Driver $T=47725 1205 0 0 $X=47725 $Y=1205
X94 VDD 79 80 VSS Write_Driver $T=57725 1205 0 0 $X=57725 $Y=1205
X95 VDD 81 82 VSS Write_Driver $T=67725 1205 0 0 $X=67725 $Y=1205
X96 VDD 83 84 VSS Write_Driver $T=77725 1205 0 0 $X=77725 $Y=1205
X158 SE 37 38 VSS VDD Diff_Sense_Amp $T=3315 1575 0 0 $X=3550 $Y=1575
X159 SE 39 40 VSS VDD Diff_Sense_Amp $T=13315 1575 0 0 $X=13550 $Y=1575
X160 SE 41 42 VSS VDD Diff_Sense_Amp $T=23315 1575 0 0 $X=23550 $Y=1575
X161 SE 43 44 VSS VDD Diff_Sense_Amp $T=33315 1575 0 0 $X=33550 $Y=1575
X162 SE 45 46 VSS VDD Diff_Sense_Amp $T=43315 1575 0 0 $X=43550 $Y=1575
X163 SE 47 48 VSS VDD Diff_Sense_Amp $T=53315 1575 0 0 $X=53550 $Y=1575
X164 SE 49 50 VSS VDD Diff_Sense_Amp $T=63315 1575 0 0 $X=63550 $Y=1575
X165 SE 51 52 VSS VDD Diff_Sense_Amp $T=73315 1570 0 0 $X=73550 $Y=1570
X225 VDD VSS YSR 53 37 54 38 68 69 55 39 56 40 71 72 ICV_1 $T=1800 7005 0 0 $X=1775 $Y=7000
X226 VDD VSS YSR 57 41 58 42 73 74 59 43 60 44 75 76 ICV_1 $T=21800 7005 0 0 $X=21775 $Y=7000
X227 VDD VSS YSR 70 45 61 46 77 78 62 47 63 48 79 80 ICV_1 $T=41800 7005 0 0 $X=41775 $Y=7000
X228 VDD VSS YSR 64 49 65 50 81 82 66 51 67 52 83 84 ICV_1 $T=61800 7005 0 0 $X=61775 $Y=7000
X229 WL4 VDD 53 54 15 VSS SRAM $T=21925 37380 0 0 $X=21900 $Y=37380
X230 WL2 VDD 53 54 17 VSS SRAM $T=21925 48235 0 0 $X=21900 $Y=48235
X231 WL4 VDD 55 56 15 VSS SRAM $T=26865 37380 0 0 $X=26840 $Y=37380
X232 WL2 VDD 55 56 17 VSS SRAM $T=26865 48235 0 0 $X=26840 $Y=48235
X233 WL5 VDD 57 58 14 VSS SRAM $T=32300 31920 0 0 $X=32275 $Y=31920
X234 WL4 VDD 57 58 15 VSS SRAM $T=32330 37380 0 0 $X=32305 $Y=37380
X235 WL3 VDD 62 63 16 VSS SRAM $T=48725 42800 0 0 $X=48700 $Y=42800
X236 WL2 VDD 62 63 17 VSS SRAM $T=48730 48235 0 0 $X=48705 $Y=48235
X237 WL7 WL6 12 VDD 13 57 58 VSS ICV_2 $T=32330 21040 0 0 $X=32305 $Y=21040
X238 WL5 WL4 WL6 WL7 14 VDD 15 12 13 62 63 VSS ICV_3 $T=48725 21040 0 0 $X=48700 $Y=21040
X239 WL1 WL0 18 VDD 19 62 63 VSS ICV_4 $T=48725 53680 0 0 $X=48700 $Y=53680
X240 WL3 WL2 WL1 WL0 VDD 16 17 18 19 57 58 VSS ICV_5 $T=32330 42800 0 0 $X=32305 $Y=42800
X241 WL6 WL4 WL5 WL7 WL3 WL0 WL1 WL2 VDD 12 13 14 15 16 17 18 19 59 60 VSS ICV_6 $T=37795 21040 0 0 $X=37770 $Y=21040
X242 WL6 WL4 WL5 WL7 WL3 WL0 WL1 WL2 VDD 12 13 14 15 16 17 18 19 70 61 VSS ICV_6 $T=43260 21040 0 0 $X=43235 $Y=21040
X243 WL6 WL4 WL5 WL7 WL3 WL0 WL1 WL2 VDD 12 13 14 15 16 17 18 19 64 65 VSS ICV_6 $T=54190 21040 0 0 $X=54165 $Y=21040
X244 WL6 WL4 WL5 WL7 WL3 WL0 WL1 WL2 VDD 12 13 14 15 16 17 18 19 66 67 VSS ICV_6 $T=59655 21040 0 0 $X=59630 $Y=21040
X245 53 54 VDD PRE VSS Pre_charge_CKT $T=19710 16395 0 0 $X=19710 $Y=16395
X246 66 67 VDD PRE VSS Pre_charge_CKT $T=57440 16395 0 0 $X=57440 $Y=16395
X247 VDD PRE VSS 55 56 57 58 ICV_7 $T=24650 16395 0 0 $X=24650 $Y=16395
X248 VDD PRE VSS 59 60 70 61 ICV_7 $T=35580 16395 0 0 $X=35580 $Y=16395
X249 VDD PRE VSS 62 63 64 65 ICV_7 $T=46510 16395 0 0 $X=46510 $Y=16395
X250 WL7 12 VDD 53 54 55 56 VSS ICV_8 $T=21925 21040 0 0 $X=21900 $Y=21040
X251 WL6 13 VDD 53 54 55 56 VSS ICV_8 $T=21925 26480 0 0 $X=21900 $Y=26480
X252 WL5 14 VDD 53 54 55 56 VSS ICV_8 $T=21925 31920 0 0 $X=21900 $Y=31920
X253 WL3 16 VDD 53 54 55 56 VSS ICV_8 $T=21925 42800 0 0 $X=21900 $Y=42800
X254 WL1 18 VDD 53 54 55 56 VSS ICV_8 $T=21925 53680 0 0 $X=21900 $Y=53680
X255 WL0 19 VDD 53 54 55 56 VSS ICV_8 $T=21925 59115 0 0 $X=21900 $Y=59115
X256 EN 28 20 30 32 VSS NAND_3IP $T=19530 27010 1 270 $X=15685 $Y=23570
X257 EN 29 21 30 32 VSS NAND_3IP $T=19535 32450 1 270 $X=15690 $Y=29010
X258 EN 28 23 31 32 VSS NAND_3IP $T=19535 37890 1 270 $X=15690 $Y=34450
X259 EN 29 22 31 32 VSS NAND_3IP $T=19535 43330 1 270 $X=15690 $Y=39890
X260 EN 28 24 30 33 VSS NAND_3IP $T=19535 48770 1 270 $X=15690 $Y=45330
X261 EN 29 25 30 33 VSS NAND_3IP $T=19535 54210 1 270 $X=15690 $Y=50770
X262 EN 28 26 31 33 VSS NAND_3IP $T=19535 59650 1 270 $X=15690 $Y=56210
X263 EN 29 27 31 33 VSS NAND_3IP $T=19535 65090 1 270 $X=15690 $Y=61650
.ENDS
***************************************
