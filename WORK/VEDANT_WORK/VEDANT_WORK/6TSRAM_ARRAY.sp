* SPICE NETLIST
***************************************

.SUBCKT pmos_18_CDNS_784497317980 1 2 3 4
** N=4 EP=4 IP=0 FDC=1
M0 2 3 1 4 P L=1.8e-07 W=4.2e-07 $X=480 $Y=0 $D=6
.ENDS
***************************************
.SUBCKT nmos_18_CDNS_784497317981 1 2 3 4
** N=4 EP=4 IP=0 FDC=1
M0 2 3 1 4 N L=1.8e-07 W=4.2e-07 $X=480 $Y=0 $D=2
.ENDS
***************************************
.SUBCKT ML_M3_S_CDNS_7844973179817
** N=1 EP=0 IP=0 FDC=0
.ENDS
***************************************
.SUBCKT M3_M2_S_CDNS_7844973179813
** N=1 EP=0 IP=0 FDC=0
.ENDS
***************************************
.SUBCKT CMOS_inv VIN VDD OUT VSS
** N=4 EP=4 IP=10 FDC=2
X0 VDD OUT VIN VDD pmos_18_CDNS_784497317980 $T=430 1640 0 0 $X=0 $Y=1210
X1 VSS OUT VIN VSS nmos_18_CDNS_784497317981 $T=430 350 0 0 $X=250 $Y=0
.ENDS
***************************************
.SUBCKT M2_M1_S_CDNS_784497317982
** N=1 EP=0 IP=0 FDC=0
.ENDS
***************************************
.SUBCKT Write_Driver 1 WD_BL DIN WD_BLB 5
** N=6 EP=5 IP=13 FDC=6
X0 6 1 WD_BL 5 CMOS_inv $T=25 1570 0 0 $X=0 $Y=845
X1 DIN 1 WD_BLB 5 CMOS_inv $T=2025 1570 0 0 $X=2000 $Y=845
X2 DIN 1 6 5 CMOS_inv $T=4025 1570 0 0 $X=4000 $Y=845
.ENDS
***************************************
.SUBCKT M3_M2_S_CDNS_784497317984
** N=1 EP=0 IP=0 FDC=0
.ENDS
***************************************
.SUBCKT M2_M1_S_CDNS_7844973179820
** N=1 EP=0 IP=0 FDC=0
.ENDS
***************************************
.SUBCKT M3_M2_S_CDNS_7844973179821
** N=2 EP=0 IP=0 FDC=0
.ENDS
***************************************
.SUBCKT M2_M1_S_CDNS_7844973179810
** N=1 EP=0 IP=0 FDC=0
.ENDS
***************************************
.SUBCKT pmos_18_CDNS_784497317985 1 2 3
** N=3 EP=3 IP=0 FDC=1
M0 2 3 1 1 P L=1.8e-07 W=4.2e-07 $X=480 $Y=0 $D=6
.ENDS
***************************************
.SUBCKT Diff_Sense_Amp SE 2 3 VOUT 5 VDD
** N=8 EP=6 IP=15 FDC=5
M0 8 2 7 5 N L=1.8e-07 W=4.2e-07 $X=2625 $Y=1300 $D=2
M1 VOUT 3 8 5 N L=1.8e-07 W=4.2e-07 $X=3345 $Y=1300 $D=2
M2 VOUT 7 VDD VDD P L=1.8e-07 W=4.2e-07 $X=3345 $Y=2840 $D=6
X3 5 8 SE 5 nmos_18_CDNS_784497317981 $T=645 1300 0 0 $X=465 $Y=950
X11 VDD 7 7 pmos_18_CDNS_784497317985 $T=3285 2840 1 180 $X=1715 $Y=2410
.ENDS
***************************************
.SUBCKT M2_M1_S_CDNS_784497317980
** N=1 EP=0 IP=0 FDC=0
.ENDS
***************************************
.SUBCKT M3_M2_S_CDNS_784497317987
** N=1 EP=0 IP=0 FDC=0
.ENDS
***************************************
.SUBCKT Column_Mux 1 BL SA_BL BLB SA_BLB WD_BL WD_BLB 8 9
** N=10 EP=9 IP=59 FDC=10
X0 BL SA_BL 1 8 pmos_18_CDNS_784497317980 $T=2430 3560 0 0 $X=2000 $Y=3130
X1 BLB SA_BLB 1 8 pmos_18_CDNS_784497317980 $T=4430 3560 0 0 $X=4000 $Y=3130
X2 BL WD_BL 10 8 pmos_18_CDNS_784497317980 $T=6430 3560 0 0 $X=6000 $Y=3130
X3 BLB WD_BLB 10 8 pmos_18_CDNS_784497317980 $T=8430 3560 0 0 $X=8000 $Y=3130
X4 SA_BL BL 10 9 nmos_18_CDNS_784497317981 $T=3565 2270 1 180 $X=2245 $Y=1920
X5 SA_BLB BLB 10 9 nmos_18_CDNS_784497317981 $T=5575 2270 1 180 $X=4255 $Y=1920
X6 WD_BL BL 1 9 nmos_18_CDNS_784497317981 $T=7570 2270 1 180 $X=6250 $Y=1920
X7 WD_BLB BLB 1 9 nmos_18_CDNS_784497317981 $T=9570 2270 1 180 $X=8250 $Y=1920
X8 1 8 10 9 CMOS_inv $T=0 1920 0 0 $X=-25 $Y=1195
.ENDS
***************************************
.SUBCKT ICV_1 1 2 3 4 5 6 7 8 9 10 11 12 13 14 15
** N=15 EP=15 IP=18 FDC=20
X0 3 4 5 6 7 8 9 1 2 Column_Mux $T=0 0 0 0 $X=-25 $Y=-5
X1 3 10 11 12 13 14 15 1 2 Column_Mux $T=10000 0 0 0 $X=9975 $Y=-5
.ENDS
***************************************
.SUBCKT pmos_18_CDNS_784497317989 1 2 3
** N=3 EP=3 IP=0 FDC=1
M0 2 3 1 1 P L=1.8e-07 W=2.2e-07 $X=420 $Y=0 $D=6
.ENDS
***************************************
.SUBCKT nmos_18_CDNS_7844973179810 1 2 3 4
** N=4 EP=4 IP=0 FDC=1
M0 2 3 1 4 N L=1.8e-07 W=2.2e-07 $X=420 $Y=0 $D=2
.ENDS
***************************************
.SUBCKT nmos_18_CDNS_784497317988 1 2 3
** N=3 EP=3 IP=0 FDC=1
M0 2 3 1 1 N L=1.8e-07 W=4.4e-07 $X=480 $Y=0 $D=2
.ENDS
***************************************
.SUBCKT M3_M2_S_CDNS_7844973179825
** N=2 EP=0 IP=0 FDC=0
.ENDS
***************************************
.SUBCKT M2_M1_S_CDNS_7844973179826
** N=2 EP=0 IP=0 FDC=0
.ENDS
***************************************
.SUBCKT SRAM WL VDD BL BLB VSS
** N=7 EP=5 IP=33 FDC=6
X4 VDD 7 6 pmos_18_CDNS_784497317989 $T=2040 4110 1 180 $X=490 $Y=3580
X5 VDD 6 7 pmos_18_CDNS_784497317989 $T=2600 4110 0 0 $X=2070 $Y=3580
X6 BL 7 WL VSS nmos_18_CDNS_7844973179810 $T=1280 660 0 90 $X=610 $Y=380
X7 6 BLB WL VSS nmos_18_CDNS_7844973179810 $T=3620 1680 1 270 $X=2950 $Y=380
X8 VSS 7 6 nmos_18_CDNS_784497317988 $T=2100 2310 1 180 $X=780 $Y=1960
X9 VSS 6 7 nmos_18_CDNS_784497317988 $T=2540 2310 0 0 $X=2360 $Y=1960
.ENDS
***************************************
.SUBCKT ICV_2 1 2 3 4 5 6
** N=6 EP=6 IP=10 FDC=12
X0 1 3 5 6 2 SRAM $T=0 0 0 0 $X=-25 $Y=0
X1 4 3 5 6 2 SRAM $T=10 5435 0 0 $X=-15 $Y=5435
.ENDS
***************************************
.SUBCKT M3_M2_S_CDNS_7844973179823
** N=2 EP=0 IP=0 FDC=0
.ENDS
***************************************
.SUBCKT Pre_charge_CKT BL BLB 3 4 5
** N=6 EP=5 IP=14 FDC=5
M0 BLB 6 BL 3 P L=1.8e-07 W=4.2e-07 $X=3655 $Y=2365 $D=6
M1 3 6 BLB 3 P L=1.8e-07 W=4.2e-07 $X=4375 $Y=2365 $D=6
X2 3 BL 6 3 pmos_18_CDNS_784497317980 $T=2455 2785 1 0 $X=2025 $Y=1935
X4 4 3 6 5 CMOS_inv $T=25 725 0 0 $X=0 $Y=0
.ENDS
***************************************
.SUBCKT ICV_3 1 2 3 4 5 6
** N=6 EP=6 IP=10 FDC=12
X0 1 3 5 6 2 SRAM $T=0 0 0 0 $X=-25 $Y=0
X1 4 3 5 6 2 SRAM $T=0 5440 0 0 $X=-25 $Y=5440
.ENDS
***************************************
.SUBCKT ICV_4 1 2 3 4 5 6 7 8 9 10 11 12
** N=12 EP=12 IP=28 FDC=48
X0 1 3 11 12 2 SRAM $T=0 21760 0 0 $X=-25 $Y=21760
X1 4 3 11 12 2 SRAM $T=0 27195 0 0 $X=-25 $Y=27195
X2 5 2 3 6 11 12 ICV_2 $T=-5 32640 0 0 $X=-30 $Y=32640
X3 7 2 3 8 11 12 ICV_3 $T=0 0 0 0 $X=-25 $Y=0
X4 9 2 3 10 11 12 ICV_3 $T=0 10880 0 0 $X=-25 $Y=10880
.ENDS
***************************************
.SUBCKT ICV_5 1 2 3 4 5 6 7
** N=7 EP=7 IP=10 FDC=10
X0 4 5 1 2 3 Pre_charge_CKT $T=0 0 0 0 $X=0 $Y=0
X1 6 7 1 2 3 Pre_charge_CKT $T=5465 0 0 0 $X=5465 $Y=0
.ENDS
***************************************
.SUBCKT ICV_6 1 2 3 4 5 6 7
** N=7 EP=7 IP=10 FDC=12
X0 1 3 4 5 2 SRAM $T=0 0 0 0 $X=-25 $Y=0
X1 1 3 6 7 2 SRAM $T=4940 0 0 0 $X=4915 $Y=0
.ENDS
***************************************
.SUBCKT nmos_18_CDNS_7844973179811 1 2 3 4
** N=4 EP=4 IP=0 FDC=1
M0 2 3 1 4 N L=1.8e-07 W=4.2e-07 $X=480 $Y=0 $D=2
.ENDS
***************************************
.SUBCKT NAND_3IP 1 C Y B A VSS
** N=8 EP=6 IP=20 FDC=6
M0 Y C 1 1 P L=1.8e-07 W=4.2e-07 $X=910 $Y=1640 $D=6
M1 1 B Y 1 P L=1.8e-07 W=4.2e-07 $X=1630 $Y=1640 $D=6
X7 1 Y A pmos_18_CDNS_784497317985 $T=1870 1640 0 0 $X=1540 $Y=1210
X8 VSS 7 C VSS nmos_18_CDNS_7844973179811 $T=430 350 0 0 $X=250 $Y=0
X9 7 8 B VSS nmos_18_CDNS_7844973179811 $T=1150 350 0 0 $X=970 $Y=0
X10 8 Y A VSS nmos_18_CDNS_7844973179811 $T=1870 350 0 0 $X=1690 $Y=0
.ENDS
***************************************
.SUBCKT 6TSRAM_ARRAY VDD EN VSS WL7 WL6 WL4 WL5 WL3 WL2 WL1 WL0 OUT0 OUT1 OUT2 OUT3 OUT4 OUT5 OUT6 OUT7 PRE
+ YSR SE D0 D1 D2 D3 D4 D5 D6 D7
** N=92 EP=30 IP=614 FDC=662
X0 4 EN WL7 VSS CMOS_inv $T=17760 22365 1 270 $X=14840 $Y=20365
X1 6 EN WL6 VSS CMOS_inv $T=17760 27805 1 270 $X=14840 $Y=25805
X2 8 EN WL4 VSS CMOS_inv $T=17760 38685 1 270 $X=14840 $Y=36685
X3 10 EN WL5 VSS CMOS_inv $T=17765 33245 1 270 $X=14845 $Y=31245
X4 12 EN WL3 VSS CMOS_inv $T=17765 44125 1 270 $X=14845 $Y=42125
X5 14 EN WL2 VSS CMOS_inv $T=17765 49565 1 270 $X=14845 $Y=47565
X6 16 EN WL1 VSS CMOS_inv $T=17765 55005 1 270 $X=14845 $Y=53005
X7 18 EN WL0 VSS CMOS_inv $T=17765 60445 1 270 $X=14845 $Y=58445
X8 20 EN 21 VSS CMOS_inv $T=17765 65885 1 270 $X=14845 $Y=63885
X9 22 EN 23 VSS CMOS_inv $T=17765 67885 1 270 $X=14845 $Y=65885
X10 24 EN 25 VSS CMOS_inv $T=17765 69885 1 270 $X=14845 $Y=67885
X68 VDD 76 D0 77 VSS Write_Driver $T=5955 0 0 0 $X=5955 $Y=0
X69 VDD 79 D1 80 VSS Write_Driver $T=15955 0 0 0 $X=15955 $Y=0
X70 VDD 81 D2 82 VSS Write_Driver $T=25955 0 0 0 $X=25955 $Y=0
X71 VDD 83 D3 84 VSS Write_Driver $T=35955 0 0 0 $X=35955 $Y=0
X72 VDD 85 D4 86 VSS Write_Driver $T=45955 0 0 0 $X=45955 $Y=0
X73 VDD 87 D5 88 VSS Write_Driver $T=55955 0 0 0 $X=55955 $Y=0
X74 VDD 89 D6 90 VSS Write_Driver $T=65955 0 0 0 $X=65955 $Y=0
X75 VDD 91 D7 92 VSS Write_Driver $T=75955 0 0 0 $X=75955 $Y=0
X137 SE 45 46 OUT0 VSS VDD Diff_Sense_Amp $T=1545 370 0 0 $X=1780 $Y=370
X138 SE 47 48 OUT1 VSS VDD Diff_Sense_Amp $T=11545 370 0 0 $X=11780 $Y=370
X139 SE 49 50 OUT2 VSS VDD Diff_Sense_Amp $T=21545 370 0 0 $X=21780 $Y=370
X140 SE 51 52 OUT3 VSS VDD Diff_Sense_Amp $T=31545 370 0 0 $X=31780 $Y=370
X141 SE 53 54 OUT4 VSS VDD Diff_Sense_Amp $T=41545 370 0 0 $X=41780 $Y=370
X142 SE 55 56 OUT5 VSS VDD Diff_Sense_Amp $T=51545 370 0 0 $X=51780 $Y=370
X143 SE 57 58 OUT6 VSS VDD Diff_Sense_Amp $T=61370 370 0 0 $X=61605 $Y=370
X144 SE 59 60 OUT7 VSS VDD Diff_Sense_Amp $T=71540 370 0 0 $X=71775 $Y=370
X212 VDD VSS YSR 61 45 62 46 76 77 63 47 64 48 79 80 ICV_1 $T=30 5800 0 0 $X=5 $Y=5795
X213 VDD VSS YSR 65 49 66 50 81 82 67 51 68 52 83 84 ICV_1 $T=20030 5800 0 0 $X=20005 $Y=5795
X214 VDD VSS YSR 78 53 69 54 85 86 70 55 71 56 87 88 ICV_1 $T=40030 5800 0 0 $X=40005 $Y=5795
X215 VDD VSS YSR 72 57 73 58 89 90 74 59 75 60 91 92 ICV_1 $T=60030 5800 0 0 $X=60005 $Y=5795
X216 WL4 VDD 61 62 VSS SRAM $T=20150 36155 0 0 $X=20125 $Y=36155
X217 WL1 VDD 61 62 VSS SRAM $T=20150 52475 0 0 $X=20125 $Y=52475
X218 WL1 VDD 63 64 VSS SRAM $T=25085 52475 0 0 $X=25060 $Y=52475
X219 WL4 VDD 63 64 VSS SRAM $T=25090 36155 0 0 $X=25065 $Y=36155
X220 WL7 VDD 74 75 VSS SRAM $T=57875 19835 0 0 $X=57850 $Y=19835
X221 WL5 VDD 74 75 VSS SRAM $T=57875 30715 0 0 $X=57850 $Y=30715
X222 WL3 VDD 74 75 VSS SRAM $T=57875 41595 0 0 $X=57850 $Y=41595
X223 WL6 VDD 74 75 VSS SRAM $T=57880 25275 0 0 $X=57855 $Y=25275
X224 WL4 VDD 74 75 VSS SRAM $T=57880 36155 0 0 $X=57855 $Y=36155
X225 WL2 VDD 74 75 VSS SRAM $T=57880 47030 0 0 $X=57855 $Y=47030
X226 WL1 VSS VDD WL0 74 75 ICV_2 $T=57875 52475 0 0 $X=57850 $Y=52475
X227 61 62 VDD PRE VSS Pre_charge_CKT $T=17940 15190 0 0 $X=17940 $Y=15190
X228 74 75 VDD PRE VSS Pre_charge_CKT $T=55670 15190 0 0 $X=55670 $Y=15190
X229 WL3 VSS VDD WL2 WL1 WL0 WL7 WL6 WL5 WL4 65 66 ICV_4 $T=30555 19835 0 0 $X=30525 $Y=19835
X230 WL3 VSS VDD WL2 WL1 WL0 WL7 WL6 WL5 WL4 67 68 ICV_4 $T=36020 19835 0 0 $X=35990 $Y=19835
X231 WL3 VSS VDD WL2 WL1 WL0 WL7 WL6 WL5 WL4 78 69 ICV_4 $T=41485 19835 0 0 $X=41455 $Y=19835
X232 WL3 VSS VDD WL2 WL1 WL0 WL7 WL6 WL5 WL4 70 71 ICV_4 $T=46950 19835 0 0 $X=46920 $Y=19835
X233 WL3 VSS VDD WL2 WL1 WL0 WL7 WL6 WL5 WL4 72 73 ICV_4 $T=52415 19835 0 0 $X=52385 $Y=19835
X234 VDD PRE VSS 63 64 65 66 ICV_5 $T=22880 15190 0 0 $X=22880 $Y=15190
X235 VDD PRE VSS 67 68 78 69 ICV_5 $T=33810 15190 0 0 $X=33810 $Y=15190
X236 VDD PRE VSS 70 71 72 73 ICV_5 $T=44740 15190 0 0 $X=44740 $Y=15190
X237 WL7 VSS VDD 61 62 63 64 ICV_6 $T=20150 19835 0 0 $X=20125 $Y=19835
X238 WL6 VSS VDD 61 62 63 64 ICV_6 $T=20150 25275 0 0 $X=20125 $Y=25275
X239 WL5 VSS VDD 61 62 63 64 ICV_6 $T=20150 30715 0 0 $X=20125 $Y=30715
X240 WL3 VSS VDD 61 62 63 64 ICV_6 $T=20150 41595 0 0 $X=20125 $Y=41595
X241 WL2 VSS VDD 61 62 63 64 ICV_6 $T=20150 47030 0 0 $X=20125 $Y=47030
X242 WL0 VSS VDD 61 62 63 64 ICV_6 $T=20155 57910 0 0 $X=20130 $Y=57910
X243 EN 20 4 22 24 VSS NAND_3IP $T=17760 25805 1 270 $X=13915 $Y=22365
X244 EN 21 6 22 24 VSS NAND_3IP $T=17765 31245 1 270 $X=13920 $Y=27805
X245 EN 20 10 23 24 VSS NAND_3IP $T=17765 36685 1 270 $X=13920 $Y=33245
X246 EN 21 8 23 24 VSS NAND_3IP $T=17765 42125 1 270 $X=13920 $Y=38685
X247 EN 20 12 22 25 VSS NAND_3IP $T=17765 47565 1 270 $X=13920 $Y=44125
X248 EN 21 14 22 25 VSS NAND_3IP $T=17765 53005 1 270 $X=13920 $Y=49565
X249 EN 20 16 23 25 VSS NAND_3IP $T=17765 58445 1 270 $X=13920 $Y=55005
X250 EN 21 18 23 25 VSS NAND_3IP $T=17765 63885 1 270 $X=13920 $Y=60445
.ENDS
***************************************
