* SPICE NETLIST
***************************************

.SUBCKT M2_M1_S_CDNS_783207073700
** N=1 EP=0 IP=0 FDC=0
.ENDS
***************************************
.SUBCKT pmos_18_CDNS_783207073700 1 2 3
** N=3 EP=3 IP=0 FDC=1
M0 2 3 1 1 P L=1.8e-07 W=4.2e-07 $X=480 $Y=0 $D=6
.ENDS
***************************************
.SUBCKT nmos_18_CDNS_783207073701 1 2 3 4
** N=4 EP=4 IP=0 FDC=1
M0 2 3 1 4 N L=1.8e-07 W=4.2e-07 $X=480 $Y=0 $D=2
.ENDS
***************************************
.SUBCKT M3_M2_S_CDNS_783207073705
** N=1 EP=0 IP=0 FDC=0
.ENDS
***************************************
.SUBCKT INVERTER vin vss out vdd
** N=4 EP=4 IP=8 FDC=2
X0 vdd out vin pmos_18_CDNS_783207073700 $T=430 1640 0 0 $X=0 $Y=1210
X1 vss out vin vss nmos_18_CDNS_783207073701 $T=430 350 0 0 $X=250 $Y=0
.ENDS
***************************************
.SUBCKT M2_M1_S_CDNS_783207073701
** N=1 EP=0 IP=0 FDC=0
.ENDS
***************************************
.SUBCKT NAND C B A 4 Y 6
** N=8 EP=6 IP=26 FDC=6
X0 6 Y C pmos_18_CDNS_783207073700 $T=430 1640 0 0 $X=0 $Y=1210
X1 6 Y B pmos_18_CDNS_783207073700 $T=2290 1640 1 180 $X=720 $Y=1210
X2 6 Y A pmos_18_CDNS_783207073700 $T=1870 1640 0 0 $X=1440 $Y=1210
X3 4 7 C 4 nmos_18_CDNS_783207073701 $T=430 350 0 0 $X=250 $Y=0
X4 7 8 B 4 nmos_18_CDNS_783207073701 $T=1150 350 0 0 $X=970 $Y=0
X5 8 Y A 4 nmos_18_CDNS_783207073701 $T=1870 350 0 0 $X=1690 $Y=0
.ENDS
***************************************
.SUBCKT 3_8_DECODER VDD VSS C B A Y0 Y1 Y2 Y3 Y4 Y5 Y6 Y7
** N=24 EP=13 IP=134 FDC=70
X40 A VSS 5 VDD INVERTER $T=645 3445 0 0 $X=645 $Y=2810
X41 B VSS 4 VDD INVERTER $T=2645 3445 0 0 $X=2645 $Y=2810
X42 C VSS 3 VDD INVERTER $T=4645 3445 0 0 $X=4645 $Y=2810
X43 9 VSS Y0 VDD INVERTER $T=10085 3445 0 0 $X=10085 $Y=2810
X44 11 VSS Y1 VDD INVERTER $T=15525 3445 0 0 $X=15525 $Y=2810
X45 13 VSS Y2 VDD INVERTER $T=20965 3445 0 0 $X=20965 $Y=2810
X46 15 VSS Y3 VDD INVERTER $T=26405 3445 0 0 $X=26405 $Y=2810
X47 17 VSS Y4 VDD INVERTER $T=31845 3455 0 0 $X=31845 $Y=2820
X48 19 VSS Y5 VDD INVERTER $T=37285 3445 0 0 $X=37285 $Y=2810
X49 21 VSS Y6 VDD INVERTER $T=42725 3455 0 0 $X=42725 $Y=2820
X50 23 VSS Y7 VDD INVERTER $T=48165 3445 0 0 $X=48165 $Y=2810
X53 3 4 5 VSS 9 VDD NAND $T=6645 3445 0 0 $X=6645 $Y=2810
X54 C 4 5 VSS 11 VDD NAND $T=12085 3445 0 0 $X=12085 $Y=2810
X55 3 B 5 VSS 13 VDD NAND $T=17525 3445 0 0 $X=17525 $Y=2810
X56 C B 5 VSS 15 VDD NAND $T=22965 3445 0 0 $X=22965 $Y=2810
X57 3 4 A VSS 17 VDD NAND $T=28405 3445 0 0 $X=28405 $Y=2810
X58 C 4 A VSS 19 VDD NAND $T=33845 3445 0 0 $X=33845 $Y=2810
X59 3 B A VSS 21 VDD NAND $T=39285 3445 0 0 $X=39285 $Y=2810
X60 C B A VSS 23 VDD NAND $T=44725 3445 0 0 $X=44725 $Y=2810
.ENDS
***************************************
