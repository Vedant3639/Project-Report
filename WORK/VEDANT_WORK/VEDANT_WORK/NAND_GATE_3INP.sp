* SPICE NETLIST
***************************************

.SUBCKT nmos_18_CDNS_782151476651 1 2 3 4
** N=4 EP=4 IP=0 FDC=1
M0 2 3 1 4 N L=1.8e-07 W=4.2e-07 $X=480 $Y=0 $D=2
.ENDS
***************************************
.SUBCKT M2_M1_S_CDNS_782151476651
** N=2 EP=0 IP=0 FDC=0
.ENDS
***************************************
.SUBCKT NAND_GATE_3INP
** N=8 EP=0 IP=16 FDC=6
M0 4 3 2 2 P L=1.8e-07 W=4.2e-07 $X=740 $Y=1640 $D=6
M1 2 5 4 2 P L=1.8e-07 W=4.2e-07 $X=1460 $Y=1640 $D=6
M2 4 6 2 2 P L=1.8e-07 W=4.2e-07 $X=2180 $Y=1640 $D=6
X3 1 7 3 1 nmos_18_CDNS_782151476651 $T=260 350 0 0 $X=80 $Y=0
X4 7 8 5 1 nmos_18_CDNS_782151476651 $T=980 350 0 0 $X=800 $Y=0
X5 8 4 6 1 nmos_18_CDNS_782151476651 $T=1700 350 0 0 $X=1520 $Y=0
.ENDS
***************************************
