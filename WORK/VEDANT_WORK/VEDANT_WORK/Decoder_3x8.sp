* SPICE NETLIST
***************************************

.SUBCKT M2_M1_S_CDNS_782224472092
** N=1 EP=0 IP=0 FDC=0
.ENDS
***************************************
.SUBCKT M2_M1_S_CDNS_782224472090
** N=2 EP=0 IP=0 FDC=0
.ENDS
***************************************
.SUBCKT ML_M3_S_CDNS_782224472097
** N=1 EP=0 IP=0 FDC=0
.ENDS
***************************************
.SUBCKT M3_M2_S_CDNS_782224472096
** N=1 EP=0 IP=0 FDC=0
.ENDS
***************************************
.SUBCKT CMOS_INV vss vdd vin out
** N=4 EP=4 IP=2 FDC=2
M0 out vin vss vss N L=1.8e-07 W=4.2e-07 $X=910 $Y=385 $D=2
M1 out vin vdd vdd P L=1.8e-07 W=4.2e-07 $X=910 $Y=1670 $D=6
.ENDS
***************************************
.SUBCKT nmos_18_CDNS_782224472093 1 2 3 4
** N=4 EP=4 IP=0 FDC=1
M0 2 3 1 4 N L=1.8e-07 W=4.2e-07 $X=480 $Y=0 $D=2
.ENDS
***************************************
.SUBCKT NAND_GATE_3INP 1 2 C Y B A
** N=8 EP=6 IP=13 FDC=6
M0 7 C 1 1 N L=1.8e-07 W=4.2e-07 $X=910 $Y=960 $D=2
M1 Y C 2 2 P L=1.8e-07 W=4.2e-07 $X=910 $Y=2250 $D=6
M2 2 B Y 2 P L=1.8e-07 W=4.2e-07 $X=1630 $Y=2250 $D=6
M3 Y A 2 2 P L=1.8e-07 W=4.2e-07 $X=2350 $Y=2250 $D=6
X9 7 8 B 1 nmos_18_CDNS_782224472093 $T=1150 960 0 0 $X=970 $Y=610
X10 8 Y A 1 nmos_18_CDNS_782224472093 $T=1870 960 0 0 $X=1690 $Y=610
.ENDS
***************************************
.SUBCKT Decoder_3x8 A B C CBAR ABAR BBAR Y3 Y4 Y5 Y6 Y7 Y0 Y1 Y2
** N=24 EP=14 IP=173 FDC=70
X42 2 1 A ABAR CMOS_INV $T=9110 200 0 90 $X=6110 $Y=200
X43 2 1 B BBAR CMOS_INV $T=9110 2200 0 90 $X=6110 $Y=2200
X44 2 1 C CBAR CMOS_INV $T=9110 4200 0 90 $X=6110 $Y=4200
X45 2 1 6 Y0 CMOS_INV $T=9110 9640 0 90 $X=6110 $Y=9640
X46 2 1 7 Y1 CMOS_INV $T=9110 15080 0 90 $X=6110 $Y=15080
X47 2 1 8 Y2 CMOS_INV $T=9110 20520 0 90 $X=6110 $Y=20520
X48 2 1 9 Y3 CMOS_INV $T=9110 25960 0 90 $X=6110 $Y=25960
X49 2 1 10 Y4 CMOS_INV $T=9110 31400 0 90 $X=6110 $Y=31400
X50 2 1 11 Y5 CMOS_INV $T=9110 36840 0 90 $X=6110 $Y=36840
X51 2 1 12 Y6 CMOS_INV $T=9110 42280 0 90 $X=6110 $Y=42280
X52 2 1 13 Y7 CMOS_INV $T=9110 47720 0 90 $X=6110 $Y=47720
X53 2 1 CBAR 6 BBAR ABAR NAND_GATE_3INP $T=9690 6200 0 90 $X=5795 $Y=6200
X54 2 1 C 7 BBAR ABAR NAND_GATE_3INP $T=9690 11640 0 90 $X=5795 $Y=11640
X55 2 1 CBAR 8 B ABAR NAND_GATE_3INP $T=9690 17080 0 90 $X=5795 $Y=17080
X56 2 1 C 9 B ABAR NAND_GATE_3INP $T=9690 22520 0 90 $X=5795 $Y=22520
X57 2 1 CBAR 10 BBAR A NAND_GATE_3INP $T=9690 27960 0 90 $X=5795 $Y=27960
X58 2 1 C 11 BBAR A NAND_GATE_3INP $T=9690 33400 0 90 $X=5795 $Y=33400
X59 2 1 CBAR 12 B A NAND_GATE_3INP $T=9690 38840 0 90 $X=5795 $Y=38840
X60 2 1 C 13 B A NAND_GATE_3INP $T=9690 44280 0 90 $X=5795 $Y=44280
.ENDS
***************************************
