* SPICE NETLIST
***************************************

.SUBCKT pmos_18_CDNS_782042633150 1 2 3
** N=3 EP=3 IP=0 FDC=1
M0 2 3 1 1 P L=1.8e-07 W=4.2e-07 $X=480 $Y=0 $D=6
.ENDS
***************************************
.SUBCKT nmos_18_CDNS_782042633151 1 2 3 4
** N=4 EP=4 IP=0 FDC=1
M0 2 3 1 4 N L=1.8e-07 W=4.2e-07 $X=480 $Y=0 $D=2
.ENDS
***************************************
.SUBCKT M2_M1_S_CDNS_782042633150
** N=1 EP=0 IP=0 FDC=0
.ENDS
***************************************
.SUBCKT NAND VSS VDD Y C B A
** N=8 EP=6 IP=25 FDC=6
X0 VDD Y C pmos_18_CDNS_782042633150 $T=3740 5950 0 0 $X=3310 $Y=5520
X1 VDD Y B pmos_18_CDNS_782042633150 $T=5600 5950 1 180 $X=4030 $Y=5520
X2 VDD Y A pmos_18_CDNS_782042633150 $T=5180 5950 0 0 $X=4750 $Y=5520
X3 VSS 3 C VSS nmos_18_CDNS_782042633151 $T=3740 4660 0 0 $X=3560 $Y=4310
X4 3 4 B VSS nmos_18_CDNS_782042633151 $T=4460 4660 0 0 $X=4280 $Y=4310
X5 4 Y A VSS nmos_18_CDNS_782042633151 $T=5180 4660 0 0 $X=5000 $Y=4310
.ENDS
***************************************
