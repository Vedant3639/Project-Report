* SPICE NETLIST
***************************************

.SUBCKT pmos_18_CDNS_782836671202 1 2 3 4
** N=4 EP=4 IP=0 FDC=1
M0 2 3 1 4 P L=1.8e-07 W=2.2e-07 $X=420 $Y=0 $D=6
.ENDS
***************************************
.SUBCKT nmos_18_CDNS_782836671200 1 2 3 4
** N=4 EP=4 IP=0 FDC=1
M0 2 3 1 4 N L=1.8e-07 W=2.2e-07 $X=420 $Y=0 $D=2
.ENDS
***************************************
.SUBCKT nmos_18_CDNS_782836671201 1 2 3 4
** N=4 EP=4 IP=0 FDC=1
M0 2 3 1 4 N L=1.8e-07 W=4.4e-07 $X=480 $Y=0 $D=2
.ENDS
***************************************
.SUBCKT M2_M1_S_CDNS_782836671208
** N=2 EP=0 IP=0 FDC=0
.ENDS
***************************************
.SUBCKT M3_M2_S_CDNS_782836671207
** N=2 EP=0 IP=0 FDC=0
.ENDS
***************************************
.SUBCKT M2_M1_S_CDNS_782836671201
** N=1 EP=0 IP=0 FDC=0
.ENDS
***************************************
.SUBCKT SRAM WL VDD VSS
** N=9 EP=3 IP=34 FDC=6
X0 VDD 3 2 8 pmos_18_CDNS_782836671202 $T=1835 3665 1 180 $X=285 $Y=3135
X1 VDD 2 3 8 pmos_18_CDNS_782836671202 $T=2395 3665 0 0 $X=1865 $Y=3135
X2 5 3 WL 9 nmos_18_CDNS_782836671200 $T=1055 210 0 90 $X=385 $Y=-70
X3 2 6 WL 9 nmos_18_CDNS_782836671200 $T=3170 1230 0 270 $X=2720 $Y=-70
X4 VSS 3 2 9 nmos_18_CDNS_782836671201 $T=1895 1860 1 180 $X=575 $Y=1510
X5 VSS 2 3 9 nmos_18_CDNS_782836671201 $T=2335 1860 0 0 $X=2155 $Y=1510
.ENDS
***************************************
