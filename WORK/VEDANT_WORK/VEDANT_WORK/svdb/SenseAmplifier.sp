* SPICE NETLIST
***************************************

.SUBCKT nmos_18_CDNS_781848520741 1 2 3 4
** N=4 EP=4 IP=0 FDC=1
M0 2 3 1 4 N L=1.8e-07 W=4.2e-07 AD=2.016e-13 AS=2.016e-13 PD=1.8e-06 PS=1.8e-06 $X=480 $Y=0 $D=2
.ENDS
***************************************
.SUBCKT pmos_18_CDNS_781848520740 1 2 3
** N=3 EP=3 IP=0 FDC=1
M0 2 3 1 1 P L=1.8e-07 W=4.2e-07 AD=2.016e-13 AS=2.016e-13 PD=1.8e-06 PS=1.8e-06 $X=480 $Y=0 $D=6
.ENDS
***************************************
.SUBCKT SenseAmplifier
** N=8 EP=0 IP=14 FDC=5
M0 3 7 2 2 N L=1.8e-07 W=4.2e-07 AD=2.016e-13 AS=2.016e-13 PD=1.8e-06 PS=1.8e-06 $X=2625 $Y=1785 $D=2
X1 3 4 6 2 nmos_18_CDNS_781848520741 $T=1280 2845 0 90 $X=510 $Y=2665
X2 3 5 8 2 nmos_18_CDNS_781848520741 $T=5320 2845 0 90 $X=4550 $Y=2665
X3 1 4 4 pmos_18_CDNS_781848520740 $T=2250 4705 0 270 $X=1820 $Y=3135
X4 1 5 4 pmos_18_CDNS_781848520740 $T=3530 4705 0 270 $X=3100 $Y=3135
.ENDS
***************************************
