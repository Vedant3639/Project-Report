* SPICE NETLIST
***************************************

.SUBCKT nmos_18_CDNS_781273346830 1 2 3 4
** N=4 EP=4 IP=0 FDC=1
M0 2 3 1 4 N L=1.8e-07 W=4.2e-07 AD=2.016e-13 AS=2.016e-13 PD=1.8e-06 PS=1.8e-06 $X=480 $Y=0 $D=2
.ENDS
***************************************
.SUBCKT nmos_18_CDNS_781273346833 1 2 3
** N=3 EP=3 IP=0 FDC=1
M0 2 3 1 1 N L=1.8e-07 W=4.2e-07 AD=2.016e-13 AS=2.016e-13 PD=1.8e-06 PS=1.8e-06 $X=480 $Y=0 $D=2
.ENDS
***************************************
.SUBCKT M3_M2_S_CDNS_781273346833
** N=1 EP=0 IP=0 FDC=0
.ENDS
***************************************
.SUBCKT M2_M1_S_CDNS_781273346831
** N=1 EP=0 IP=0 FDC=0
.ENDS
***************************************
.SUBCKT 6TSRAM
** N=8 EP=0 IP=18 FDC=6
M0 3 8 2 3 P L=1.8e-07 W=4.2e-07 AD=2.016e-13 AS=2.016e-13 PD=1.8e-06 PS=1.8e-06 $X=3620 $Y=1705 $D=6
M1 4 8 3 3 P L=1.8e-07 W=4.2e-07 AD=2.016e-13 AS=2.016e-13 PD=1.8e-06 PS=1.8e-06 $X=4900 $Y=2425 $D=6
X2 5 2 1 7 nmos_18_CDNS_781273346830 $T=880 2365 0 270 $X=530 $Y=1045
X3 4 6 1 7 nmos_18_CDNS_781273346830 $T=7680 3085 0 270 $X=7330 $Y=1765
X4 7 2 8 nmos_18_CDNS_781273346833 $T=2000 2365 0 270 $X=1650 $Y=1045
X5 7 4 8 nmos_18_CDNS_781273346833 $T=6980 1945 0 90 $X=6210 $Y=835
.ENDS
***************************************
