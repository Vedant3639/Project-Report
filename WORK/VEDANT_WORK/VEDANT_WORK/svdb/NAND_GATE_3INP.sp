* SPICE NETLIST
***************************************

.SUBCKT pmos_18_CDNS_781797669400 1 2 3
** N=3 EP=3 IP=0 FDC=1
M0 2 3 1 1 P L=1.8e-07 W=4.2e-07 AD=2.016e-13 AS=2.016e-13 PD=1.8e-06 PS=1.8e-06 $X=480 $Y=0 $D=6
.ENDS
***************************************
.SUBCKT nmos_18_CDNS_781797669401 1 2 3 4
** N=4 EP=4 IP=0 FDC=1
M0 2 3 1 4 N L=1.8e-07 W=4.2e-07 AD=2.016e-13 AS=2.016e-13 PD=1.8e-06 PS=1.8e-06 $X=480 $Y=0 $D=2
.ENDS
***************************************
.SUBCKT NAND_GATE_3INP
** N=8 EP=0 IP=17 FDC=6
M0 3 8 2 2 N L=1.8e-07 W=4.2e-07 AD=2.016e-13 AS=2.016e-13 PD=1.8e-06 PS=1.8e-06 $X=5080 $Y=1505 $D=2
X1 1 5 6 pmos_18_CDNS_781797669400 $T=400 6620 0 0 $X=-30 $Y=6190
X2 1 5 7 pmos_18_CDNS_781797669400 $T=2400 6620 0 0 $X=1970 $Y=6190
X3 1 5 8 pmos_18_CDNS_781797669400 $T=4400 6620 0 0 $X=3970 $Y=6190
X4 3 4 7 2 nmos_18_CDNS_781797669401 $T=5500 2525 0 90 $X=4730 $Y=2345
X5 4 5 6 2 nmos_18_CDNS_781797669401 $T=5500 4025 0 90 $X=4730 $Y=3845
.ENDS
***************************************
