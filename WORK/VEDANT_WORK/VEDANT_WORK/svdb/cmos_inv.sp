* SPICE NETLIST
***************************************

.SUBCKT cmos_inv
** N=4 EP=0 IP=0 FDC=2
M0 4 1 3 3 N L=1.8e-07 W=4.2e-07 AD=2.016e-13 AS=2.016e-13 PD=1.8e-06 PS=1.8e-06 $X=1510 $Y=-5600 $D=2
M1 4 1 2 2 P L=1.8e-07 W=4.2e-07 AD=2.016e-13 AS=2.016e-13 PD=1.8e-06 PS=1.8e-06 $X=1510 $Y=-3150 $D=6
.ENDS
***************************************
