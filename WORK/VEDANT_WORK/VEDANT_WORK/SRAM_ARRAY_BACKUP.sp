* SPICE NETLIST
***************************************

.SUBCKT M3_M2_S_CDNS_783597538837
** N=1 EP=0 IP=0 FDC=0
.ENDS
***************************************
.SUBCKT M3_M2_S_CDNS_783597538833
** N=1 EP=0 IP=0 FDC=0
.ENDS
***************************************
.SUBCKT M3_M2_S_CDNS_7835975388319
** N=2 EP=0 IP=0 FDC=0
.ENDS
***************************************
.SUBCKT M2_M1_S_CDNS_7835975388320
** N=1 EP=0 IP=0 FDC=0
.ENDS
***************************************
.SUBCKT ML_M3_S_CDNS_7835975388318
** N=1 EP=0 IP=0 FDC=0
.ENDS
***************************************
.SUBCKT SenseAmplifier SA_BLB VDD SA_BL 4 SE VSS
** N=8 EP=6 IP=8 FDC=5
M0 8 SA_BLB VOUT VSS N L=1.8e-07 W=4.2e-07 $X=1035 $Y=1835 $D=2
M1 4 SA_BL 8 VSS N L=1.8e-07 W=4.2e-07 $X=1755 $Y=1835 $D=2
M2 VSS SE 8 VSS N L=1.8e-07 W=4.2e-07 $X=3255 $Y=1835 $D=2
M3 VDD 4 VOUT VDD P L=1.8e-07 W=4.2e-07 $X=1035 $Y=3125 $D=6
M4 4 4 VDD VDD P L=1.8e-07 W=4.2e-07 $X=1755 $Y=3125 $D=6
.ENDS
***************************************
.SUBCKT pmos_18_CDNS_783597538836 1 2 3 4
** N=4 EP=4 IP=0 FDC=1
M0 2 3 1 4 P L=1.8e-07 W=4.2e-07 $X=480 $Y=0 $D=6
.ENDS
***************************************
.SUBCKT nmos_18_CDNS_783597538835 1 2 3 4
** N=4 EP=4 IP=0 FDC=1
M0 2 3 1 4 N L=1.8e-07 W=4.2e-07 $X=480 $Y=0 $D=2
.ENDS
***************************************
.SUBCKT M3_M2_S_CDNS_7835975388337
** N=1 EP=0 IP=0 FDC=0
.ENDS
***************************************
.SUBCKT CMOS_INV vin vdd out vss
** N=4 EP=4 IP=10 FDC=2
X1 vdd out vin vdd pmos_18_CDNS_783597538836 $T=430 1670 0 0 $X=0 $Y=1240
X2 vss out vin vss nmos_18_CDNS_783597538835 $T=430 385 0 0 $X=250 $Y=35
.ENDS
***************************************
.SUBCKT Write_Driver 1 WD_BLB WD_BL VDD
** N=6 EP=4 IP=12 FDC=6
X0 5 VDD WD_BLB 1 CMOS_INV $T=2155 760 1 180 $X=155 $Y=175
X1 Din VDD 5 1 CMOS_INV $T=3655 760 1 180 $X=1655 $Y=175
X2 Din VDD WD_BL 1 CMOS_INV $T=3380 760 0 0 $X=3380 $Y=175
.ENDS
***************************************
.SUBCKT M2_M1_S_CDNS_783597538832
** N=1 EP=0 IP=0 FDC=0
.ENDS
***************************************
.SUBCKT M2_M1_S_CDNS_7835975388330
** N=1 EP=0 IP=0 FDC=0
.ENDS
***************************************
.SUBCKT M2_M1_S_CDNS_7835975388311
** N=1 EP=0 IP=0 FDC=0
.ENDS
***************************************
.SUBCKT M1_PO_4X_CDNS_7835975388331
** N=1 EP=0 IP=0 FDC=0
.ENDS
***************************************
.SUBCKT ColumnMux YSR 2 BLB BL 5 6 7 8 9
** N=10 EP=9 IP=60 FDC=10
X3 2 BLB YSR_BAR 9 pmos_18_CDNS_783597538836 $T=1570 3735 1 180 $X=0 $Y=3305
X4 BL 5 YSR_BAR 9 pmos_18_CDNS_783597538836 $T=3570 3735 1 180 $X=2000 $Y=3305
X5 BLB 6 YSR 9 pmos_18_CDNS_783597538836 $T=5570 3735 1 180 $X=4000 $Y=3305
X6 7 BL YSR 9 pmos_18_CDNS_783597538836 $T=7070 3735 1 180 $X=5500 $Y=3305
X7 2 BLB YSR 8 nmos_18_CDNS_783597538835 $T=1570 2450 1 180 $X=250 $Y=2100
X8 BL 5 YSR 8 nmos_18_CDNS_783597538835 $T=3570 2450 1 180 $X=2250 $Y=2100
X9 BLB 6 YSR_BAR 8 nmos_18_CDNS_783597538835 $T=5570 2450 1 180 $X=4250 $Y=2100
X10 7 BL YSR_BAR 8 nmos_18_CDNS_783597538835 $T=7070 2450 1 180 $X=5750 $Y=2100
X11 YSR 9 YSR_BAR 8 CMOS_INV $T=7500 2065 0 0 $X=7500 $Y=1480
.ENDS
***************************************
.SUBCKT ICV_1 1 2 3 4 5 6 7 8 9 10 11 12 13 14 15
** N=15 EP=15 IP=18 FDC=20
X0 3 4 7 6 5 8 9 1 2 ColumnMux $T=0 0 0 0 $X=0 $Y=-285
X1 3 10 13 12 11 14 15 1 2 ColumnMux $T=9000 0 0 0 $X=9000 $Y=-285
.ENDS
***************************************
.SUBCKT pmos_18_CDNS_783597538839 1 2 3
** N=3 EP=3 IP=0 FDC=1
M0 2 3 1 1 P L=1.8e-07 W=2.2e-07 $X=420 $Y=0 $D=6
.ENDS
***************************************
.SUBCKT nmos_18_CDNS_783597538837 1 2 3 4
** N=4 EP=4 IP=0 FDC=1
M0 2 3 1 4 N L=1.8e-07 W=2.2e-07 $X=420 $Y=0 $D=2
.ENDS
***************************************
.SUBCKT nmos_18_CDNS_783597538838 1 2 3
** N=3 EP=3 IP=0 FDC=1
M0 2 3 1 1 N L=1.8e-07 W=4.4e-07 $X=480 $Y=0 $D=2
.ENDS
***************************************
.SUBCKT SRAM WL VDD BL 4 VSS
** N=7 EP=5 IP=28 FDC=6
X6 VDD 7 6 pmos_18_CDNS_783597538839 $T=1835 3665 1 180 $X=285 $Y=3135
X7 VDD 6 7 pmos_18_CDNS_783597538839 $T=2395 3665 0 0 $X=1865 $Y=3135
X8 BL 7 WL VSS nmos_18_CDNS_783597538837 $T=1055 210 0 90 $X=385 $Y=-70
X9 6 4 WL VSS nmos_18_CDNS_783597538837 $T=3170 1230 0 270 $X=2720 $Y=-70
X10 VSS 7 6 nmos_18_CDNS_783597538838 $T=1895 1860 1 180 $X=575 $Y=1510
X11 VSS 6 7 nmos_18_CDNS_783597538838 $T=2335 1860 0 0 $X=2155 $Y=1510
.ENDS
***************************************
.SUBCKT ICV_2 1 2 3 4 5 6 7
** N=7 EP=7 IP=10 FDC=12
X0 3 2 4 5 1 SRAM $T=0 0 0 0 $X=-260 $Y=-545
X1 3 2 6 7 1 SRAM $T=4440 0 0 0 $X=4180 $Y=-545
.ENDS
***************************************
.SUBCKT ICV_3 1 2 3 4 5 6 7 8
** N=8 EP=8 IP=14 FDC=24
X0 1 2 3 5 6 7 8 ICV_2 $T=0 0 0 0 $X=-260 $Y=-545
X1 1 2 4 5 6 7 8 ICV_2 $T=0 5445 0 0 $X=-260 $Y=4900
.ENDS
***************************************
.SUBCKT Precharge_Circuit 1 BL BLB 4 5
** N=6 EP=5 IP=6 FDC=5
M0 BL 6 1 1 P L=1.8e-07 W=4.2e-07 $X=2650 $Y=2335 $D=6
M1 BLB 6 BL 1 P L=1.8e-07 W=4.2e-07 $X=3370 $Y=2335 $D=6
M2 1 6 BLB 1 P L=1.8e-07 W=4.2e-07 $X=4090 $Y=2335 $D=6
X5 5 1 6 4 CMOS_INV $T=240 665 0 0 $X=240 $Y=80
.ENDS
***************************************
.SUBCKT ICV_4 1 2 3 4 5 6 7
** N=7 EP=7 IP=10 FDC=10
X0 2 5 3 7 1 Precharge_Circuit $T=0 0 0 0 $X=240 $Y=80
X1 2 6 4 7 1 Precharge_Circuit $T=4440 0 0 0 $X=4680 $Y=80
.ENDS
***************************************
.SUBCKT ICV_5 1 2 3 4 5 6 7 8 9
** N=9 EP=9 IP=12 FDC=18
X0 3 2 4 5 1 SRAM $T=8880 -10 0 0 $X=8620 $Y=-555
X1 1 2 3 6 7 8 9 ICV_2 $T=0 0 0 0 $X=-260 $Y=-545
.ENDS
***************************************
.SUBCKT ICV_6 1 2 3 4 5 6 7 8 9 10 11
** N=11 EP=11 IP=14 FDC=24
X0 1 2 3 4 5 6 7 ICV_2 $T=0 0 0 0 $X=-260 $Y=-545
X1 1 2 3 8 9 10 11 ICV_2 $T=8880 0 0 0 $X=8620 $Y=-545
.ENDS
***************************************
.SUBCKT INVERTER vin vdd out vss
** N=4 EP=4 IP=9 FDC=2
X0 vdd out vin vdd pmos_18_CDNS_783597538836 $T=430 1640 0 0 $X=0 $Y=1210
X1 vss out vin vss nmos_18_CDNS_783597538835 $T=430 350 0 0 $X=250 $Y=0
.ENDS
***************************************
.SUBCKT NAND C B A 4 Y 6
** N=8 EP=6 IP=29 FDC=6
X0 4 Y C 4 pmos_18_CDNS_783597538836 $T=430 1640 0 0 $X=0 $Y=1210
X1 4 Y B 4 pmos_18_CDNS_783597538836 $T=2290 1640 1 180 $X=720 $Y=1210
X2 4 Y A 4 pmos_18_CDNS_783597538836 $T=1870 1640 0 0 $X=1440 $Y=1210
X3 6 7 C 6 nmos_18_CDNS_783597538835 $T=430 350 0 0 $X=250 $Y=0
X4 7 8 B 6 nmos_18_CDNS_783597538835 $T=1150 350 0 0 $X=970 $Y=0
X5 8 Y A 6 nmos_18_CDNS_783597538835 $T=1870 350 0 0 $X=1690 $Y=0
.ENDS
***************************************
.SUBCKT 3_8_DECODER VDD VSS Y0 Y1 Y2 Y3 Y4 Y5 Y6 Y7
** N=24 EP=10 IP=134 FDC=70
X42 A VDD 13 VSS INVERTER $T=645 3445 0 0 $X=645 $Y=2810
X43 B VDD 12 VSS INVERTER $T=2645 3445 0 0 $X=2645 $Y=2810
X44 C VDD 11 VSS INVERTER $T=4645 3445 0 0 $X=4645 $Y=2810
X45 17 VDD Y0 VSS INVERTER $T=10085 3445 0 0 $X=10085 $Y=2810
X46 18 VDD Y1 VSS INVERTER $T=15525 3445 0 0 $X=15525 $Y=2810
X47 19 VDD Y2 VSS INVERTER $T=20965 3445 0 0 $X=20965 $Y=2810
X48 20 VDD Y3 VSS INVERTER $T=26405 3445 0 0 $X=26405 $Y=2810
X49 21 VDD Y4 VSS INVERTER $T=31845 3455 0 0 $X=31845 $Y=2820
X50 22 VDD Y5 VSS INVERTER $T=37285 3445 0 0 $X=37285 $Y=2810
X51 23 VDD Y6 VSS INVERTER $T=42725 3455 0 0 $X=42725 $Y=2820
X52 24 VDD Y7 VSS INVERTER $T=48165 3445 0 0 $X=48165 $Y=2810
X53 11 12 13 VDD 17 VSS NAND $T=6645 3445 0 0 $X=6645 $Y=2810
X54 C 12 13 VDD 18 VSS NAND $T=12085 3445 0 0 $X=12085 $Y=2810
X55 11 B 13 VDD 19 VSS NAND $T=17525 3445 0 0 $X=17525 $Y=2810
X56 C B 13 VDD 20 VSS NAND $T=22965 3445 0 0 $X=22965 $Y=2810
X57 11 12 A VDD 21 VSS NAND $T=28405 3445 0 0 $X=28405 $Y=2810
X58 C 12 A VDD 22 VSS NAND $T=33845 3445 0 0 $X=33845 $Y=2810
X59 11 B A VDD 23 VSS NAND $T=39285 3445 0 0 $X=39285 $Y=2810
X60 C B A VDD 24 VSS NAND $T=44725 3445 0 0 $X=44725 $Y=2810
.ENDS
***************************************
.SUBCKT SRAM_ARRAY_BACKUP VDD VSS PRE YSR WL6 WL7 WL5 WL4 WL3 WL0 WL2 WL1 WL_EN SE
** N=120 EP=14 IP=469 FDC=662
X86 65 VDD 105 3 SE VSS SenseAmplifier $T=21975 -81535 0 0 $X=21975 $Y=-82220
X87 78 VDD 107 4 SE VSS SenseAmplifier $T=30985 -81535 0 0 $X=30985 $Y=-82220
X88 82 VDD 109 5 SE VSS SenseAmplifier $T=39985 -81535 0 0 $X=39985 $Y=-82220
X89 86 VDD 111 VDD SE VSS SenseAmplifier $T=48975 -81535 0 0 $X=48975 $Y=-82220
X90 90 VDD 113 6 SE VSS SenseAmplifier $T=57975 -81535 0 0 $X=57975 $Y=-82220
X91 96 VDD 115 7 SE VSS SenseAmplifier $T=66985 -81535 0 0 $X=66985 $Y=-82220
X92 100 VDD 117 8 SE VSS SenseAmplifier $T=75985 -81535 0 0 $X=75985 $Y=-82220
X93 102 VDD 119 9 SE VSS SenseAmplifier $T=84975 -81535 0 0 $X=84975 $Y=-82220
X94 VSS 103 62 VDD Write_Driver $T=17515 -76085 0 0 $X=17670 $Y=-76345
X95 VSS 106 67 VDD Write_Driver $T=26515 -76085 0 0 $X=26670 $Y=-76345
X96 VSS 108 79 VDD Write_Driver $T=35515 -76085 0 0 $X=35670 $Y=-76345
X97 VSS 110 83 VDD Write_Driver $T=44515 -76085 0 0 $X=44670 $Y=-76345
X98 VSS 112 88 VDD Write_Driver $T=53525 -76085 0 0 $X=53680 $Y=-76345
X99 VSS 114 94 VDD Write_Driver $T=62515 -76085 0 0 $X=62670 $Y=-76345
X100 VSS 116 99 VDD Write_Driver $T=71515 -76085 0 0 $X=71670 $Y=-76345
X101 VSS 118 101 VDD Write_Driver $T=80515 -76085 0 0 $X=80670 $Y=-76345
X110 YSR 112 89 87 88 90 113 VSS VDD ColumnMux $T=52950 -69080 0 0 $X=52950 $Y=-69365
X111 YSR 114 92 91 94 96 115 VSS VDD ColumnMux $T=61960 -69080 0 0 $X=61960 $Y=-69365
X112 VSS VDD YSR 103 62 63 64 65 105 106 67 69 77 78 107 ICV_1 $T=16950 -69080 0 0 $X=16950 $Y=-69365
X113 VSS VDD YSR 108 79 80 81 82 109 110 83 84 85 86 111 ICV_1 $T=34950 -69080 0 0 $X=34950 $Y=-69365
X114 VSS VDD YSR 116 99 93 95 100 117 118 101 97 98 102 119 ICV_1 $T=70950 -69080 0 0 $X=70950 $Y=-69365
X115 WL7 VDD 63 64 VSS SRAM $T=36855 -46395 0 0 $X=36595 $Y=-46940
X116 WL7 VDD 69 77 VSS SRAM $T=41295 -46405 0 0 $X=41035 $Y=-46950
X117 WL2 VDD 81 80 VSS SRAM $T=45735 -19085 0 0 $X=45475 $Y=-19630
X118 WL0 VDD 81 80 VSS SRAM $T=45735 -8200 0 0 $X=45475 $Y=-8745
X119 WL2 VDD 84 85 VSS SRAM $T=50175 -19095 0 0 $X=49915 $Y=-19640
X120 WL3 VDD 87 89 VSS SRAM $T=54605 -24515 0 0 $X=54345 $Y=-25060
X121 WL4 VDD 97 98 VSS SRAM $T=67935 -30000 0 0 $X=67675 $Y=-30545
X122 WL0 VDD 97 98 VSS SRAM $T=67935 -8150 0 0 $X=67675 $Y=-8695
X123 VSS VDD WL3 63 64 69 77 ICV_2 $T=36855 -24525 0 0 $X=36595 $Y=-25070
X124 VSS VDD WL2 63 64 69 77 ICV_2 $T=36855 -19085 0 0 $X=36595 $Y=-19630
X125 VSS VDD WL0 63 64 69 77 ICV_2 $T=36855 -8150 0 0 $X=36595 $Y=-8695
X126 VSS VDD WL3 81 80 84 85 ICV_2 $T=45735 -24515 0 0 $X=45475 $Y=-25060
X127 VSS VDD WL7 93 95 97 98 ICV_2 $T=63495 -46395 0 0 $X=63235 $Y=-46940
X128 VSS VDD WL1 93 95 97 98 ICV_2 $T=63495 -13605 0 0 $X=63235 $Y=-14150
X129 VSS VDD WL6 WL5 63 64 69 77 ICV_3 $T=36855 -40830 0 0 $X=36595 $Y=-41375
X130 VSS VDD WL6 WL5 81 80 84 85 ICV_3 $T=45735 -40830 0 0 $X=45475 $Y=-41375
X131 VSS VDD WL6 WL5 87 89 91 92 ICV_3 $T=54615 -40830 0 0 $X=54355 $Y=-41375
X132 VSS VDD WL6 WL5 93 95 97 98 ICV_3 $T=63495 -40830 0 0 $X=63235 $Y=-41375
X133 PRE VDD 64 77 63 69 VSS ICV_4 $T=34700 -51915 0 0 $X=34940 $Y=-51835
X134 PRE VDD 80 85 81 84 VSS ICV_4 $T=43580 -51915 0 0 $X=43820 $Y=-51835
X135 PRE VDD 89 92 87 91 VSS ICV_4 $T=52460 -51915 0 0 $X=52700 $Y=-51835
X136 PRE VDD 95 98 93 97 VSS ICV_4 $T=61340 -51915 0 0 $X=61580 $Y=-51835
X137 VSS VDD WL1 81 80 63 64 69 77 ICV_5 $T=36855 -13605 0 0 $X=36595 $Y=-14160
X138 VSS VDD WL1 91 92 84 85 87 89 ICV_5 $T=50175 -13605 0 0 $X=49915 $Y=-14160
X139 VSS VDD WL4 93 95 87 89 91 92 ICV_5 $T=54615 -30000 0 0 $X=54355 $Y=-30555
X140 VSS VDD WL3 97 98 91 92 93 95 ICV_5 $T=59055 -24515 0 0 $X=58795 $Y=-25070
X141 VSS VDD WL4 63 64 69 77 81 80 84 85 ICV_6 $T=36855 -30000 0 0 $X=36595 $Y=-30545
X142 VSS VDD WL7 81 80 84 85 87 89 91 92 ICV_6 $T=45735 -46395 0 0 $X=45475 $Y=-46940
X143 VSS VDD WL0 84 85 87 89 91 92 93 95 ICV_6 $T=50175 -8150 0 0 $X=49915 $Y=-8695
X144 VSS VDD WL2 87 89 91 92 93 95 97 98 ICV_6 $T=54615 -19085 0 0 $X=54355 $Y=-19630
X145 WL_EN VSS WL0 WL1 WL2 WL3 WL4 WL5 WL6 WL7 3_8_DECODER $T=29460 4630 1 270 $X=17300 $Y=-47180
.ENDS
***************************************
